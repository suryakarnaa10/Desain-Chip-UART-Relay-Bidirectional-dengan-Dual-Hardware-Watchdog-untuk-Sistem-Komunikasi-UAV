* NGSPICE file created from sistem_lengkap.ext - technology: sky130A

* Black-box entry subcircuit for sky130_fd_sc_hd__tapvpwrvgnd_1 abstract view
.subckt sky130_fd_sc_hd__tapvpwrvgnd_1 VGND VPWR
.ends

* Black-box entry subcircuit for sky130_fd_sc_hd__dfxtp_1 abstract view
.subckt sky130_fd_sc_hd__dfxtp_1 CLK D VGND VNB VPB VPWR Q
.ends

* Black-box entry subcircuit for sky130_fd_sc_hd__fill_1 abstract view
.subckt sky130_fd_sc_hd__fill_1 VGND VNB VPB VPWR
.ends

* Black-box entry subcircuit for sky130_ef_sc_hd__decap_12 abstract view
.subckt sky130_ef_sc_hd__decap_12 VPWR VGND VPB VNB
.ends

* Black-box entry subcircuit for sky130_fd_sc_hd__decap_8 abstract view
.subckt sky130_fd_sc_hd__decap_8 VGND VNB VPB VPWR
.ends

* Black-box entry subcircuit for sky130_fd_sc_hd__a31o_1 abstract view
.subckt sky130_fd_sc_hd__a31o_1 A1 A2 A3 B1 VGND VNB VPB VPWR X
.ends

* Black-box entry subcircuit for sky130_fd_sc_hd__and2_1 abstract view
.subckt sky130_fd_sc_hd__and2_1 A B VGND VNB VPB VPWR X
.ends

* Black-box entry subcircuit for sky130_fd_sc_hd__decap_4 abstract view
.subckt sky130_fd_sc_hd__decap_4 VGND VNB VPB VPWR
.ends

* Black-box entry subcircuit for sky130_fd_sc_hd__o21a_1 abstract view
.subckt sky130_fd_sc_hd__o21a_1 A1 A2 B1 VGND VNB VPB VPWR X
.ends

* Black-box entry subcircuit for sky130_fd_sc_hd__a21o_1 abstract view
.subckt sky130_fd_sc_hd__a21o_1 A1 A2 B1 VGND VNB VPB VPWR X
.ends

* Black-box entry subcircuit for sky130_fd_sc_hd__o21ba_1 abstract view
.subckt sky130_fd_sc_hd__o21ba_1 A1 A2 B1_N VGND VNB VPB VPWR X
.ends

* Black-box entry subcircuit for sky130_fd_sc_hd__dlygate4sd3_1 abstract view
.subckt sky130_fd_sc_hd__dlygate4sd3_1 A VGND VNB VPB VPWR X
.ends

* Black-box entry subcircuit for sky130_fd_sc_hd__fill_2 abstract view
.subckt sky130_fd_sc_hd__fill_2 VGND VNB VPB VPWR
.ends

* Black-box entry subcircuit for sky130_fd_sc_hd__and4_1 abstract view
.subckt sky130_fd_sc_hd__and4_1 A B C D VGND VNB VPB VPWR X
.ends

* Black-box entry subcircuit for sky130_fd_sc_hd__buf_6 abstract view
.subckt sky130_fd_sc_hd__buf_6 A VGND VNB VPB VPWR X
.ends

* Black-box entry subcircuit for sky130_fd_sc_hd__decap_3 abstract view
.subckt sky130_fd_sc_hd__decap_3 VGND VNB VPB VPWR
.ends

* Black-box entry subcircuit for sky130_fd_sc_hd__a21oi_1 abstract view
.subckt sky130_fd_sc_hd__a21oi_1 A1 A2 B1 VGND VNB VPB VPWR Y
.ends

* Black-box entry subcircuit for sky130_fd_sc_hd__nor2_1 abstract view
.subckt sky130_fd_sc_hd__nor2_1 A B VGND VNB VPB VPWR Y
.ends

* Black-box entry subcircuit for sky130_fd_sc_hd__decap_6 abstract view
.subckt sky130_fd_sc_hd__decap_6 VGND VNB VPB VPWR
.ends

* Black-box entry subcircuit for sky130_fd_sc_hd__and3_1 abstract view
.subckt sky130_fd_sc_hd__and3_1 A B C VGND VNB VPB VPWR X
.ends

* Black-box entry subcircuit for sky130_fd_sc_hd__dfrtp_1 abstract view
.subckt sky130_fd_sc_hd__dfrtp_1 CLK D RESET_B VGND VNB VPB VPWR Q
.ends

* Black-box entry subcircuit for sky130_fd_sc_hd__or4_1 abstract view
.subckt sky130_fd_sc_hd__or4_1 A B C D VGND VNB VPB VPWR X
.ends

* Black-box entry subcircuit for sky130_fd_sc_hd__clkbuf_4 abstract view
.subckt sky130_fd_sc_hd__clkbuf_4 A VGND VNB VPB VPWR X
.ends

* Black-box entry subcircuit for sky130_fd_sc_hd__inv_2 abstract view
.subckt sky130_fd_sc_hd__inv_2 A VGND VNB VPB VPWR Y
.ends

* Black-box entry subcircuit for sky130_fd_sc_hd__nand2_1 abstract view
.subckt sky130_fd_sc_hd__nand2_1 A B VGND VNB VPB VPWR Y
.ends

* Black-box entry subcircuit for sky130_fd_sc_hd__mux2_1 abstract view
.subckt sky130_fd_sc_hd__mux2_1 A0 A1 S VGND VNB VPB VPWR X
.ends

* Black-box entry subcircuit for sky130_fd_sc_hd__or3_2 abstract view
.subckt sky130_fd_sc_hd__or3_2 A B C VGND VNB VPB VPWR X
.ends

* Black-box entry subcircuit for sky130_fd_sc_hd__clkbuf_1 abstract view
.subckt sky130_fd_sc_hd__clkbuf_1 A VGND VNB VPB VPWR X
.ends

* Black-box entry subcircuit for sky130_fd_sc_hd__or2_1 abstract view
.subckt sky130_fd_sc_hd__or2_1 A B VGND VNB VPB VPWR X
.ends

* Black-box entry subcircuit for sky130_fd_sc_hd__or4_4 abstract view
.subckt sky130_fd_sc_hd__or4_4 A B C D VGND VNB VPB VPWR X
.ends

* Black-box entry subcircuit for sky130_fd_sc_hd__o21ai_1 abstract view
.subckt sky130_fd_sc_hd__o21ai_1 A1 A2 B1 VGND VNB VPB VPWR Y
.ends

* Black-box entry subcircuit for sky130_fd_sc_hd__xnor2_1 abstract view
.subckt sky130_fd_sc_hd__xnor2_1 A B VGND VNB VPB VPWR Y
.ends

* Black-box entry subcircuit for sky130_fd_sc_hd__nand3_1 abstract view
.subckt sky130_fd_sc_hd__nand3_1 A B C VGND VNB VPB VPWR Y
.ends

* Black-box entry subcircuit for sky130_fd_sc_hd__a311o_1 abstract view
.subckt sky130_fd_sc_hd__a311o_1 A1 A2 A3 B1 C1 VGND VNB VPB VPWR X
.ends

* Black-box entry subcircuit for sky130_fd_sc_hd__xor2_1 abstract view
.subckt sky130_fd_sc_hd__xor2_1 A B VGND VNB VPB VPWR X
.ends

* Black-box entry subcircuit for sky130_fd_sc_hd__or2_2 abstract view
.subckt sky130_fd_sc_hd__or2_2 A B VGND VNB VPB VPWR X
.ends

* Black-box entry subcircuit for sky130_fd_sc_hd__nor3_1 abstract view
.subckt sky130_fd_sc_hd__nor3_1 A B C VGND VNB VPB VPWR Y
.ends

* Black-box entry subcircuit for sky130_fd_sc_hd__clkbuf_2 abstract view
.subckt sky130_fd_sc_hd__clkbuf_2 A VGND VNB VPB VPWR X
.ends

* Black-box entry subcircuit for sky130_fd_sc_hd__dfstp_1 abstract view
.subckt sky130_fd_sc_hd__dfstp_1 CLK D SET_B VGND VNB VPB VPWR Q
.ends

* Black-box entry subcircuit for sky130_fd_sc_hd__or2b_1 abstract view
.subckt sky130_fd_sc_hd__or2b_1 A B_N VGND VNB VPB VPWR X
.ends

* Black-box entry subcircuit for sky130_fd_sc_hd__and2b_1 abstract view
.subckt sky130_fd_sc_hd__and2b_1 A_N B VGND VNB VPB VPWR X
.ends

* Black-box entry subcircuit for sky130_fd_sc_hd__o211a_1 abstract view
.subckt sky130_fd_sc_hd__o211a_1 A1 A2 B1 C1 VGND VNB VPB VPWR X
.ends

* Black-box entry subcircuit for sky130_fd_sc_hd__nand4_1 abstract view
.subckt sky130_fd_sc_hd__nand4_1 A B C D VGND VNB VPB VPWR Y
.ends

* Black-box entry subcircuit for sky130_fd_sc_hd__and3b_1 abstract view
.subckt sky130_fd_sc_hd__and3b_1 A_N B C VGND VNB VPB VPWR X
.ends

* Black-box entry subcircuit for sky130_fd_sc_hd__dfrtp_2 abstract view
.subckt sky130_fd_sc_hd__dfrtp_2 CLK D RESET_B VGND VNB VPB VPWR Q
.ends

* Black-box entry subcircuit for sky130_fd_sc_hd__clkbuf_16 abstract view
.subckt sky130_fd_sc_hd__clkbuf_16 A VGND VNB VPB VPWR X
.ends

* Black-box entry subcircuit for sky130_fd_sc_hd__or3_1 abstract view
.subckt sky130_fd_sc_hd__or3_1 A B C VGND VNB VPB VPWR X
.ends

* Black-box entry subcircuit for sky130_fd_sc_hd__dfstp_2 abstract view
.subckt sky130_fd_sc_hd__dfstp_2 CLK D SET_B VGND VNB VPB VPWR Q
.ends

* Black-box entry subcircuit for sky130_fd_sc_hd__buf_4 abstract view
.subckt sky130_fd_sc_hd__buf_4 A VGND VNB VPB VPWR X
.ends

* Black-box entry subcircuit for sky130_fd_sc_hd__a21boi_1 abstract view
.subckt sky130_fd_sc_hd__a21boi_1 A1 A2 B1_N VGND VNB VPB VPWR Y
.ends

* Black-box entry subcircuit for sky130_fd_sc_hd__a311oi_1 abstract view
.subckt sky130_fd_sc_hd__a311oi_1 A1 A2 A3 B1 C1 VGND VNB VPB VPWR Y
.ends

* Black-box entry subcircuit for sky130_fd_sc_hd__a211oi_1 abstract view
.subckt sky130_fd_sc_hd__a211oi_1 A1 A2 B1 C1 VGND VNB VPB VPWR Y
.ends

* Black-box entry subcircuit for sky130_fd_sc_hd__buf_1 abstract view
.subckt sky130_fd_sc_hd__buf_1 A VGND VNB VPB VPWR X
.ends

* Black-box entry subcircuit for sky130_fd_sc_hd__dfxtp_2 abstract view
.subckt sky130_fd_sc_hd__dfxtp_2 CLK D VGND VNB VPB VPWR Q
.ends

* Black-box entry subcircuit for sky130_fd_sc_hd__buf_2 abstract view
.subckt sky130_fd_sc_hd__buf_2 A VGND VNB VPB VPWR X
.ends

* Black-box entry subcircuit for sky130_fd_sc_hd__or3b_1 abstract view
.subckt sky130_fd_sc_hd__or3b_1 A B C_N VGND VNB VPB VPWR X
.ends

* Black-box entry subcircuit for sky130_fd_sc_hd__o221a_1 abstract view
.subckt sky130_fd_sc_hd__o221a_1 A1 A2 B1 B2 C1 VGND VNB VPB VPWR X
.ends

* Black-box entry subcircuit for sky130_fd_sc_hd__or4b_1 abstract view
.subckt sky130_fd_sc_hd__or4b_1 A B C D_N VGND VNB VPB VPWR X
.ends

* Black-box entry subcircuit for sky130_fd_sc_hd__a221o_1 abstract view
.subckt sky130_fd_sc_hd__a221o_1 A1 A2 B1 B2 C1 VGND VNB VPB VPWR X
.ends

* Black-box entry subcircuit for sky130_fd_sc_hd__mux2_2 abstract view
.subckt sky130_fd_sc_hd__mux2_2 A0 A1 S VGND VNB VPB VPWR X
.ends

* Black-box entry subcircuit for sky130_fd_sc_hd__or2_4 abstract view
.subckt sky130_fd_sc_hd__or2_4 A B VGND VNB VPB VPWR X
.ends

* Black-box entry subcircuit for sky130_fd_sc_hd__a211o_1 abstract view
.subckt sky130_fd_sc_hd__a211o_1 A1 A2 B1 C1 VGND VNB VPB VPWR X
.ends

* Black-box entry subcircuit for sky130_fd_sc_hd__a21o_2 abstract view
.subckt sky130_fd_sc_hd__a21o_2 A1 A2 B1 VGND VNB VPB VPWR X
.ends

* Black-box entry subcircuit for sky130_fd_sc_hd__a22o_1 abstract view
.subckt sky130_fd_sc_hd__a22o_1 A1 A2 B1 B2 VGND VNB VPB VPWR X
.ends

* Black-box entry subcircuit for sky130_fd_sc_hd__dlymetal6s2s_1 abstract view
.subckt sky130_fd_sc_hd__dlymetal6s2s_1 A VGND VNB VPB VPWR X
.ends

* Black-box entry subcircuit for sky130_fd_sc_hd__a221oi_1 abstract view
.subckt sky130_fd_sc_hd__a221oi_1 A1 A2 B1 B2 C1 VGND VNB VPB VPWR Y
.ends

* Black-box entry subcircuit for sky130_fd_sc_hd__o2bb2a_1 abstract view
.subckt sky130_fd_sc_hd__o2bb2a_1 A1_N A2_N B1 B2 VGND VNB VPB VPWR X
.ends

* Black-box entry subcircuit for sky130_fd_sc_hd__or4_2 abstract view
.subckt sky130_fd_sc_hd__or4_2 A B C D VGND VNB VPB VPWR X
.ends

* Black-box entry subcircuit for sky130_fd_sc_hd__or4bb_1 abstract view
.subckt sky130_fd_sc_hd__or4bb_1 A B C_N D_N VGND VNB VPB VPWR X
.ends

* Black-box entry subcircuit for sky130_fd_sc_hd__nor3_2 abstract view
.subckt sky130_fd_sc_hd__nor3_2 A B C VGND VNB VPB VPWR Y
.ends

* Black-box entry subcircuit for sky130_fd_sc_hd__o21bai_1 abstract view
.subckt sky130_fd_sc_hd__o21bai_1 A1 A2 B1_N VGND VNB VPB VPWR Y
.ends

* Black-box entry subcircuit for sky130_fd_sc_hd__nor2_4 abstract view
.subckt sky130_fd_sc_hd__nor2_4 A B VGND VNB VPB VPWR Y
.ends

* Black-box entry subcircuit for sky130_fd_sc_hd__mux2_4 abstract view
.subckt sky130_fd_sc_hd__mux2_4 A0 A1 S VGND VNB VPB VPWR X
.ends

* Black-box entry subcircuit for sky130_fd_sc_hd__or3_4 abstract view
.subckt sky130_fd_sc_hd__or3_4 A B C VGND VNB VPB VPWR X
.ends

* Black-box entry subcircuit for sky130_fd_sc_hd__and4bb_1 abstract view
.subckt sky130_fd_sc_hd__and4bb_1 A_N B_N C D VGND VNB VPB VPWR X
.ends

* Black-box entry subcircuit for sky130_fd_sc_hd__nor4_1 abstract view
.subckt sky130_fd_sc_hd__nor4_1 A B C D VGND VNB VPB VPWR Y
.ends

* Black-box entry subcircuit for sky130_fd_sc_hd__a2111o_4 abstract view
.subckt sky130_fd_sc_hd__a2111o_4 A1 A2 B1 C1 D1 VGND VNB VPB VPWR X
.ends

* Black-box entry subcircuit for sky130_fd_sc_hd__nor2b_1 abstract view
.subckt sky130_fd_sc_hd__nor2b_1 A B_N VGND VNB VPB VPWR Y
.ends

* Black-box entry subcircuit for sky130_fd_sc_hd__o21ai_4 abstract view
.subckt sky130_fd_sc_hd__o21ai_4 A1 A2 B1 VGND VNB VPB VPWR Y
.ends

* Black-box entry subcircuit for sky130_fd_sc_hd__or3b_4 abstract view
.subckt sky130_fd_sc_hd__or3b_4 A B C_N VGND VNB VPB VPWR X
.ends

* Black-box entry subcircuit for sky130_fd_sc_hd__dfrtp_4 abstract view
.subckt sky130_fd_sc_hd__dfrtp_4 CLK D RESET_B VGND VNB VPB VPWR Q
.ends

* Black-box entry subcircuit for sky130_fd_sc_hd__nand2b_1 abstract view
.subckt sky130_fd_sc_hd__nand2b_1 A_N B VGND VNB VPB VPWR Y
.ends

* Black-box entry subcircuit for sky130_fd_sc_hd__nor3b_1 abstract view
.subckt sky130_fd_sc_hd__nor3b_1 A B C_N VGND VNB VPB VPWR Y
.ends

* Black-box entry subcircuit for sky130_fd_sc_hd__a41o_1 abstract view
.subckt sky130_fd_sc_hd__a41o_1 A1 A2 A3 A4 B1 VGND VNB VPB VPWR X
.ends

* Black-box entry subcircuit for sky130_fd_sc_hd__nand2_2 abstract view
.subckt sky130_fd_sc_hd__nand2_2 A B VGND VNB VPB VPWR Y
.ends

* Black-box entry subcircuit for sky130_fd_sc_hd__dlygate4sd1_1 abstract view
.subckt sky130_fd_sc_hd__dlygate4sd1_1 A VGND VNB VPB VPWR X
.ends

* Black-box entry subcircuit for sky130_fd_sc_hd__or4b_4 abstract view
.subckt sky130_fd_sc_hd__or4b_4 A B C D_N VGND VNB VPB VPWR X
.ends

* Black-box entry subcircuit for sky130_fd_sc_hd__a21oi_4 abstract view
.subckt sky130_fd_sc_hd__a21oi_4 A1 A2 B1 VGND VNB VPB VPWR Y
.ends

* Black-box entry subcircuit for sky130_fd_sc_hd__and4_2 abstract view
.subckt sky130_fd_sc_hd__and4_2 A B C D VGND VNB VPB VPWR X
.ends

.subckt sistem_lengkap VGND VPWR clk heartbeat_fc heartbeat_jetson initialize reset_n_fc
+ rxd_jetson rxd_raspi txd_jetson txd_raspi
XTAP_177 VGND VPWR sky130_fd_sc_hd__tapvpwrvgnd_1
XTAP_188 VGND VPWR sky130_fd_sc_hd__tapvpwrvgnd_1
X_2106_ clknet_leaf_22_clk net24 VGND VGND VPWR VPWR rst_cnt\[6\] sky130_fd_sc_hd__dfxtp_1
XTAP_199 VGND VPWR sky130_fd_sc_hd__tapvpwrvgnd_1
X_2037_ clknet_leaf_23_clk _0117_ VGND VGND VPWR VPWR uart_tx_raspi_inst.data_reg\[5\]
+ sky130_fd_sc_hd__dfxtp_1
XFILLER_0_43_92 VGND VGND VPWR VPWR sky130_fd_sc_hd__fill_1
XFILLER_0_32_214 VPWR VGND VPWR VGND sky130_ef_sc_hd__decap_12
XFILLER_0_23_225 VGND VGND VPWR VPWR sky130_fd_sc_hd__decap_8
XFILLER_0_48_15 VGND VGND VPWR VPWR sky130_fd_sc_hd__fill_1
X_1270_ dual_watchdog_inst.watchdog_fc.rising_edge_timeout.internal_count\[15\] dual_watchdog_inst.watchdog_fc.rising_edge_timeout.internal_count\[16\]
+ _0896_ _0758_ VGND VGND VPWR VPWR _0901_ sky130_fd_sc_hd__a31o_1
XFILLER_0_3_39 VPWR VGND VPWR VGND sky130_ef_sc_hd__decap_12
XFILLER_0_58_177 VGND VGND VPWR VPWR sky130_fd_sc_hd__decap_8
X_1606_ uart_rx_raspi_inst.data_reg\[2\] _0974_ VGND VGND VPWR VPWR _0456_ sky130_fd_sc_hd__and2_1
XFILLER_0_54_350 VPWR VGND VPWR VGND sky130_ef_sc_hd__decap_12
XFILLER_0_14_203 VGND VGND VPWR VPWR sky130_fd_sc_hd__fill_1
XFILLER_0_22_280 VGND VGND VPWR VPWR sky130_fd_sc_hd__decap_4
X_1537_ uart_tx_jetson_inst.prescale_reg\[6\] _0405_ net123 VGND VGND VPWR VPWR _0412_
+ sky130_fd_sc_hd__o21a_1
X_1399_ uart_rx_raspi_inst.rxd_reg _0996_ uart_rx_raspi_inst.bit_cnt\[0\] VGND VGND
+ VPWR VPWR _1000_ sky130_fd_sc_hd__a21o_1
X_1468_ _0359_ _0360_ _0345_ VGND VGND VPWR VPWR _0146_ sky130_fd_sc_hd__o21ba_1
XFILLER_0_45_361 VGND VGND VPWR VPWR sky130_fd_sc_hd__fill_1
Xhold170 uart_rx_jetson_inst.data_reg\[2\] VGND VGND VPWR VPWR net184 sky130_fd_sc_hd__dlygate4sd3_1
XFILLER_0_20_206 VGND VGND VPWR VPWR sky130_fd_sc_hd__fill_1
Xhold192 uart_rx_jetson_inst.data_reg\[6\] VGND VGND VPWR VPWR net206 sky130_fd_sc_hd__dlygate4sd3_1
Xhold181 uart_rx_jetson_inst.data_reg\[4\] VGND VGND VPWR VPWR net195 sky130_fd_sc_hd__dlygate4sd3_1
XFILLER_0_50_27 VGND VGND VPWR VPWR sky130_fd_sc_hd__fill_1
XFILLER_0_28_306 VGND VGND VPWR VPWR sky130_fd_sc_hd__fill_2
XFILLER_0_59_47 VGND VGND VPWR VPWR sky130_fd_sc_hd__fill_2
XFILLER_0_55_169 VGND VGND VPWR VPWR sky130_fd_sc_hd__decap_8
XFILLER_0_51_353 VGND VGND VPWR VPWR sky130_fd_sc_hd__decap_8
XFILLER_0_11_239 VGND VGND VPWR VPWR sky130_fd_sc_hd__decap_4
X_1253_ dual_watchdog_inst.watchdog_fc.rising_edge_timeout.internal_count\[10\] dual_watchdog_inst.watchdog_fc.rising_edge_timeout.internal_count\[11\]
+ _0882_ _0886_ VGND VGND VPWR VPWR _0889_ sky130_fd_sc_hd__and4_1
X_1322_ _0939_ VGND VGND VPWR VPWR _0940_ sky130_fd_sc_hd__buf_6
X_1184_ dual_watchdog_inst.watchdog_fc.falling_edge_timeout.internal_count\[13\] dual_watchdog_inst.watchdog_fc.falling_edge_timeout.internal_count\[12\]
+ _0834_ _0843_ VGND VGND VPWR VPWR _0845_ sky130_fd_sc_hd__and4_1
XFILLER_0_46_103 VGND VGND VPWR VPWR sky130_fd_sc_hd__decap_8
XFILLER_0_34_309 VGND VGND VPWR VPWR sky130_fd_sc_hd__fill_1
XFILLER_0_27_361 VGND VGND VPWR VPWR sky130_fd_sc_hd__fill_1
XFILLER_0_19_328 VGND VGND VPWR VPWR sky130_fd_sc_hd__fill_2
XFILLER_0_49_80 VGND VGND VPWR VPWR sky130_fd_sc_hd__decap_4
XFILLER_0_6_288 VPWR VGND VPWR VGND sky130_ef_sc_hd__decap_12
XFILLER_0_10_261 VGND VGND VPWR VPWR sky130_fd_sc_hd__decap_3
XFILLER_0_4_93 VGND VGND VPWR VPWR sky130_fd_sc_hd__fill_2
XFILLER_0_45_27 VGND VGND VPWR VPWR sky130_fd_sc_hd__fill_1
XFILLER_0_0_29 VPWR VGND VPWR VGND sky130_ef_sc_hd__decap_12
XFILLER_0_43_139 VGND VGND VPWR VPWR sky130_fd_sc_hd__fill_2
X_1871_ _0564_ net94 _0609_ VGND VGND VPWR VPWR _0283_ sky130_fd_sc_hd__a21oi_1
XFILLER_0_9_16 VGND VGND VPWR VPWR sky130_fd_sc_hd__decap_3
X_1940_ _0820_ _0655_ VGND VGND VPWR VPWR _0656_ sky130_fd_sc_hd__nor2_1
XFILLER_0_9_49 VGND VGND VPWR VPWR sky130_fd_sc_hd__decap_6
X_1236_ dual_watchdog_inst.watchdog_fc.rising_edge_timeout.internal_count\[4\] _0875_
+ net71 VGND VGND VPWR VPWR _0878_ sky130_fd_sc_hd__a21oi_1
X_1305_ rst_cnt\[2\] rst_cnt\[1\] rst_cnt\[0\] VGND VGND VPWR VPWR _0925_ sky130_fd_sc_hd__and3_1
X_2285_ clknet_leaf_29_clk _0310_ net8 VGND VGND VPWR VPWR dual_watchdog_inst.watchdog_fc.falling_edge_timeout.assert_time\[21\]
+ sky130_fd_sc_hd__dfrtp_1
XFILLER_0_19_50 VGND VGND VPWR VPWR sky130_fd_sc_hd__fill_1
XFILLER_0_59_250 VGND VGND VPWR VPWR sky130_fd_sc_hd__fill_2
X_1098_ dual_watchdog_inst.watchdog_fc.rising_edge_timeout.assert_time\[9\] _0782_
+ _0764_ VGND VGND VPWR VPWR _0783_ sky130_fd_sc_hd__a21oi_1
X_1167_ dual_watchdog_inst.watchdog_fc.falling_edge_timeout.internal_count\[7\] dual_watchdog_inst.watchdog_fc.falling_edge_timeout.internal_count\[6\]
+ _0825_ _0827_ VGND VGND VPWR VPWR _0833_ sky130_fd_sc_hd__and4_1
XFILLER_0_19_136 VGND VGND VPWR VPWR sky130_fd_sc_hd__decap_8
XFILLER_0_27_191 VGND VGND VPWR VPWR sky130_fd_sc_hd__fill_2
XFILLER_0_30_345 VGND VGND VPWR VPWR sky130_fd_sc_hd__fill_1
XFILLER_0_56_15 VGND VGND VPWR VPWR sky130_fd_sc_hd__decap_4
X_2070_ clknet_leaf_24_clk _0150_ VGND VGND VPWR VPWR uart_rx_raspi_inst.prescale_reg\[17\]
+ sky130_fd_sc_hd__dfxtp_1
XFILLER_0_56_231 VGND VGND VPWR VPWR sky130_fd_sc_hd__fill_1
X_1021_ dual_watchdog_inst.watchdog_fc.rising_edge_timeout.assert_time\[16\] dual_watchdog_inst.watchdog_fc.rising_edge_timeout.assert_time\[15\]
+ dual_watchdog_inst.watchdog_fc.rising_edge_timeout.assert_time\[14\] dual_watchdog_inst.watchdog_fc.rising_edge_timeout.assert_time\[13\]
+ VGND VGND VPWR VPWR _0724_ sky130_fd_sc_hd__or4_1
XFILLER_0_8_306 VGND VGND VPWR VPWR sky130_fd_sc_hd__fill_2
X_1854_ uart_tx_raspi_inst.prescale_reg\[11\] _0936_ VGND VGND VPWR VPWR _0616_ sky130_fd_sc_hd__nor2_1
X_1923_ _0829_ _0642_ _0643_ VGND VGND VPWR VPWR _0644_ sky130_fd_sc_hd__and3_1
X_1785_ net37 uart_rx_jetson_inst.m_axis_tvalid_reg _0961_ _0963_ VGND VGND VPWR VPWR
+ _0568_ sky130_fd_sc_hd__a31o_1
XFILLER_0_24_161 VGND VGND VPWR VPWR sky130_fd_sc_hd__fill_1
Xfanout7 net10 VGND VGND VPWR VPWR net7 sky130_fd_sc_hd__clkbuf_4
XFILLER_0_24_194 VGND VGND VPWR VPWR sky130_fd_sc_hd__fill_2
X_2199_ clknet_leaf_14_clk _0279_ VGND VGND VPWR VPWR uart_tx_raspi_inst.prescale_reg\[13\]
+ sky130_fd_sc_hd__dfxtp_1
X_2268_ clknet_leaf_28_clk _0293_ net7 VGND VGND VPWR VPWR dual_watchdog_inst.watchdog_fc.falling_edge_timeout.assert_time\[4\]
+ sky130_fd_sc_hd__dfrtp_1
X_1219_ dual_watchdog_inst.watchdog_fc.falling_edge_timeout.internal_count\[24\] _0866_
+ dual_watchdog_inst.watchdog_fc.falling_edge_timeout.internal_count\[25\] VGND VGND
+ VPWR VPWR _0868_ sky130_fd_sc_hd__a21oi_1
XFILLER_0_7_361 VGND VGND VPWR VPWR sky130_fd_sc_hd__fill_1
Xhold30 dual_watchdog_inst.watchdog_fc.rising_edge_timeout.internal_count\[9\] VGND
+ VGND VPWR VPWR net44 sky130_fd_sc_hd__dlygate4sd3_1
Xhold63 uart_tx_jetson_inst.prescale_reg\[8\] VGND VGND VPWR VPWR net77 sky130_fd_sc_hd__dlygate4sd3_1
Xhold52 dual_watchdog_inst.watchdog_fc.rising_edge_timeout.assert_time\[14\] VGND
+ VGND VPWR VPWR net66 sky130_fd_sc_hd__dlygate4sd3_1
Xhold41 uart_rx_raspi_inst.prescale_reg\[15\] VGND VGND VPWR VPWR net55 sky130_fd_sc_hd__dlygate4sd3_1
XFILLER_0_26_29 VGND VGND VPWR VPWR sky130_fd_sc_hd__decap_3
Xhold74 rst_cnt\[4\] VGND VGND VPWR VPWR net88 sky130_fd_sc_hd__dlygate4sd3_1
Xhold96 _0873_ VGND VGND VPWR VPWR net110 sky130_fd_sc_hd__dlygate4sd3_1
Xhold85 _0245_ VGND VGND VPWR VPWR net99 sky130_fd_sc_hd__dlygate4sd3_1
XFILLER_0_53_234 VGND VGND VPWR VPWR sky130_fd_sc_hd__decap_6
XFILLER_0_38_275 VGND VGND VPWR VPWR sky130_fd_sc_hd__fill_1
XFILLER_0_38_242 VGND VGND VPWR VPWR sky130_fd_sc_hd__decap_4
X_1570_ _0433_ _0434_ _0414_ VGND VGND VPWR VPWR _0174_ sky130_fd_sc_hd__a21oi_1
XTAP_348 VGND VPWR sky130_fd_sc_hd__tapvpwrvgnd_1
XTAP_337 VGND VPWR sky130_fd_sc_hd__tapvpwrvgnd_1
XTAP_326 VGND VPWR sky130_fd_sc_hd__tapvpwrvgnd_1
XTAP_315 VGND VPWR sky130_fd_sc_hd__tapvpwrvgnd_1
XTAP_304 VGND VPWR sky130_fd_sc_hd__tapvpwrvgnd_1
XFILLER_0_21_142 VGND VGND VPWR VPWR sky130_fd_sc_hd__fill_1
XFILLER_0_21_197 VGND VGND VPWR VPWR sky130_fd_sc_hd__fill_2
X_2053_ clknet_leaf_8_clk _0133_ VGND VGND VPWR VPWR uart_rx_raspi_inst.prescale_reg\[0\]
+ sky130_fd_sc_hd__dfxtp_1
XTAP_359 VGND VPWR sky130_fd_sc_hd__tapvpwrvgnd_1
X_2122_ clknet_leaf_23_clk _0202_ VGND VGND VPWR VPWR uart_rx_jetson_inst.m_axis_tdata_reg\[6\]
+ sky130_fd_sc_hd__dfxtp_1
XFILLER_0_44_212 VGND VGND VPWR VPWR sky130_fd_sc_hd__fill_2
XFILLER_0_32_72 VGND VGND VPWR VPWR sky130_fd_sc_hd__decap_6
XFILLER_0_29_220 VGND VGND VPWR VPWR sky130_fd_sc_hd__fill_1
X_1906_ _0639_ VGND VGND VPWR VPWR _0100_ sky130_fd_sc_hd__inv_2
X_1768_ _0560_ VGND VGND VPWR VPWR _0076_ sky130_fd_sc_hd__inv_2
X_1837_ net239 _0604_ _0596_ VGND VGND VPWR VPWR _0271_ sky130_fd_sc_hd__o21a_1
XFILLER_0_12_153 VGND VGND VPWR VPWR sky130_fd_sc_hd__fill_1
X_1699_ net230 _0524_ VGND VGND VPWR VPWR _0527_ sky130_fd_sc_hd__nand2_1
XFILLER_0_12_197 VPWR VGND VPWR VGND sky130_ef_sc_hd__decap_12
XFILLER_0_35_289 VGND VGND VPWR VPWR sky130_fd_sc_hd__fill_1
XFILLER_0_35_234 VGND VGND VPWR VPWR sky130_fd_sc_hd__decap_6
XFILLER_0_35_212 VPWR VGND VPWR VGND sky130_ef_sc_hd__decap_12
X_1622_ _0466_ net164 _0454_ VGND VGND VPWR VPWR _0467_ sky130_fd_sc_hd__mux2_1
XFILLER_0_26_234 VGND VGND VPWR VPWR sky130_fd_sc_hd__decap_6
XFILLER_0_5_117 VGND VGND VPWR VPWR sky130_fd_sc_hd__fill_1
X_1553_ _0414_ _0423_ VGND VGND VPWR VPWR _0168_ sky130_fd_sc_hd__nor2_1
X_1484_ uart_tx_jetson_inst.bit_cnt\[3\] uart_tx_jetson_inst.bit_cnt\[2\] uart_tx_jetson_inst.bit_cnt\[1\]
+ VGND VGND VPWR VPWR _0369_ sky130_fd_sc_hd__or3_2
XTAP_156 VGND VPWR sky130_fd_sc_hd__tapvpwrvgnd_1
XTAP_145 VGND VPWR sky130_fd_sc_hd__tapvpwrvgnd_1
XTAP_123 VGND VPWR sky130_fd_sc_hd__tapvpwrvgnd_1
XTAP_134 VGND VPWR sky130_fd_sc_hd__tapvpwrvgnd_1
XTAP_167 VGND VPWR sky130_fd_sc_hd__tapvpwrvgnd_1
XTAP_178 VGND VPWR sky130_fd_sc_hd__tapvpwrvgnd_1
XTAP_189 VGND VPWR sky130_fd_sc_hd__tapvpwrvgnd_1
XFILLER_0_49_315 VGND VGND VPWR VPWR sky130_fd_sc_hd__decap_8
XFILLER_0_27_72 VGND VGND VPWR VPWR sky130_fd_sc_hd__decap_4
X_2105_ clknet_leaf_22_clk net43 VGND VGND VPWR VPWR rst_cnt\[5\] sky130_fd_sc_hd__dfxtp_1
X_2036_ clknet_leaf_17_clk _0116_ VGND VGND VPWR VPWR uart_tx_raspi_inst.data_reg\[4\]
+ sky130_fd_sc_hd__dfxtp_1
XFILLER_0_17_223 VGND VGND VPWR VPWR sky130_fd_sc_hd__fill_1
XFILLER_0_17_278 VGND VGND VPWR VPWR sky130_fd_sc_hd__fill_2
XFILLER_0_32_226 VGND VGND VPWR VPWR sky130_fd_sc_hd__fill_1
XFILLER_0_55_318 VGND VGND VPWR VPWR sky130_fd_sc_hd__fill_2
XFILLER_0_2_109 VGND VGND VPWR VPWR sky130_fd_sc_hd__decap_8
XFILLER_0_48_27 VGND VGND VPWR VPWR sky130_fd_sc_hd__fill_1
XFILLER_0_58_189 VGND VGND VPWR VPWR sky130_fd_sc_hd__decap_6
X_1605_ _0455_ VGND VGND VPWR VPWR _0188_ sky130_fd_sc_hd__clkbuf_1
X_1536_ _0410_ VGND VGND VPWR VPWR _0411_ sky130_fd_sc_hd__inv_2
XFILLER_0_14_248 VGND VGND VPWR VPWR sky130_fd_sc_hd__decap_4
X_1398_ _0996_ _0998_ VGND VGND VPWR VPWR _0999_ sky130_fd_sc_hd__or2_1
XFILLER_0_38_82 VGND VGND VPWR VPWR sky130_fd_sc_hd__fill_2
X_1467_ _0349_ _0967_ net227 VGND VGND VPWR VPWR _0360_ sky130_fd_sc_hd__o21a_1
XFILLER_0_49_145 VPWR VGND VPWR VGND sky130_ef_sc_hd__decap_12
XFILLER_0_9_242 VPWR VGND VPWR VGND sky130_ef_sc_hd__decap_12
X_2019_ _0710_ VGND VGND VPWR VPWR _0319_ sky130_fd_sc_hd__clkbuf_1
XFILLER_0_60_321 VPWR VGND VPWR VGND sky130_ef_sc_hd__decap_12
Xhold171 uart_rx_raspi_inst.data_reg\[4\] VGND VGND VPWR VPWR net185 sky130_fd_sc_hd__dlygate4sd3_1
Xhold160 uart_tx_raspi_inst.data_reg\[3\] VGND VGND VPWR VPWR net174 sky130_fd_sc_hd__dlygate4sd3_1
Xhold182 dual_watchdog_inst.watchdog_fc.falling_edge_timeout.internal_count\[11\]
+ VGND VGND VPWR VPWR net196 sky130_fd_sc_hd__dlygate4sd3_1
Xhold193 uart_rx_jetson_inst.prescale_reg\[13\] VGND VGND VPWR VPWR net207 sky130_fd_sc_hd__dlygate4sd3_1
XFILLER_0_34_29 VGND VGND VPWR VPWR sky130_fd_sc_hd__decap_6
XFILLER_0_59_15 VPWR VGND VPWR VGND sky130_ef_sc_hd__decap_12
XFILLER_0_51_310 VGND VGND VPWR VPWR sky130_fd_sc_hd__fill_2
X_1252_ _0887_ _0888_ VGND VGND VPWR VPWR _0031_ sky130_fd_sc_hd__nor2_1
X_1321_ uart_tx_raspi_inst.prescale_reg\[18\] uart_tx_raspi_inst.prescale_reg\[17\]
+ uart_tx_raspi_inst.prescale_reg\[16\] _0938_ VGND VGND VPWR VPWR _0939_ sky130_fd_sc_hd__or4_4
X_1183_ dual_watchdog_inst.watchdog_fc.falling_edge_timeout.internal_count\[12\] _0834_
+ _0843_ VGND VGND VPWR VPWR _0844_ sky130_fd_sc_hd__and3_1
XFILLER_0_19_307 VGND VGND VPWR VPWR sky130_fd_sc_hd__decap_4
XFILLER_0_24_51 VPWR VGND VPWR VGND sky130_ef_sc_hd__decap_12
XFILLER_0_24_73 VGND VGND VPWR VPWR sky130_fd_sc_hd__decap_8
XFILLER_0_42_321 VGND VGND VPWR VPWR sky130_fd_sc_hd__fill_2
X_1519_ _0963_ _0392_ VGND VGND VPWR VPWR _0399_ sky130_fd_sc_hd__or2_1
XFILLER_0_18_340 VPWR VGND VPWR VGND sky130_ef_sc_hd__decap_12
X_1870_ uart_tx_raspi_inst.prescale_reg\[16\] _0938_ net93 VGND VGND VPWR VPWR _0626_
+ sky130_fd_sc_hd__o21ai_1
X_1304_ _0924_ VGND VGND VPWR VPWR _0048_ sky130_fd_sc_hd__clkbuf_1
X_1235_ dual_watchdog_inst.watchdog_fc.rising_edge_timeout.internal_count\[5\] dual_watchdog_inst.watchdog_fc.rising_edge_timeout.internal_count\[4\]
+ VGND VGND VPWR VPWR _0877_ sky130_fd_sc_hd__and2_1
X_1166_ net45 _0831_ VGND VGND VPWR VPWR _0027_ sky130_fd_sc_hd__xnor2_1
X_2284_ clknet_leaf_29_clk _0309_ net9 VGND VGND VPWR VPWR dual_watchdog_inst.watchdog_fc.falling_edge_timeout.assert_time\[20\]
+ sky130_fd_sc_hd__dfrtp_1
X_1097_ dual_watchdog_inst.watchdog_fc.rising_edge_timeout.assert_time\[8\] _0742_
+ VGND VGND VPWR VPWR _0782_ sky130_fd_sc_hd__and2_1
XFILLER_0_19_104 VGND VGND VPWR VPWR sky130_fd_sc_hd__decap_8
XFILLER_0_42_184 VGND VGND VPWR VPWR sky130_fd_sc_hd__fill_1
X_1999_ dual_watchdog_inst.watchdog_fc.falling_edge_timeout.assert_time\[24\] _0694_
+ dual_watchdog_inst.watchdog_fc.falling_edge_timeout.assert_time\[25\] VGND VGND
+ VPWR VPWR _0697_ sky130_fd_sc_hd__a21o_1
XFILLER_0_18_181 VPWR VGND VPWR VGND sky130_ef_sc_hd__decap_12
XFILLER_0_33_140 VGND VGND VPWR VPWR sky130_fd_sc_hd__fill_2
XFILLER_0_56_27 VGND VGND VPWR VPWR sky130_fd_sc_hd__fill_1
X_1020_ dual_watchdog_inst.watchdog_fc.rising_edge_timeout.assert_time\[24\] dual_watchdog_inst.watchdog_fc.rising_edge_timeout.assert_time\[23\]
+ dual_watchdog_inst.watchdog_fc.rising_edge_timeout.assert_time\[22\] dual_watchdog_inst.watchdog_fc.rising_edge_timeout.assert_time\[21\]
+ VGND VGND VPWR VPWR _0723_ sky130_fd_sc_hd__or4_1
XFILLER_0_8_329 VGND VGND VPWR VPWR sky130_fd_sc_hd__fill_1
X_1922_ dual_watchdog_inst.watchdog_fc.falling_edge_timeout.assert_time\[1\] dual_watchdog_inst.watchdog_fc.falling_edge_timeout.assert_time\[0\]
+ dual_watchdog_inst.watchdog_fc.falling_edge_timeout.assert_time\[2\] VGND VGND VPWR
+ VPWR _0643_ sky130_fd_sc_hd__nand3_1
X_1853_ _0614_ _0615_ VGND VGND VPWR VPWR _0276_ sky130_fd_sc_hd__nor2_1
X_1784_ _0565_ _0930_ _0566_ _0567_ _1002_ VGND VGND VPWR VPWR _0255_ sky130_fd_sc_hd__a311o_1
Xfanout8 net10 VGND VGND VPWR VPWR net8 sky130_fd_sc_hd__clkbuf_4
XFILLER_0_21_85 VGND VGND VPWR VPWR sky130_fd_sc_hd__fill_2
XFILLER_0_21_96 VGND VGND VPWR VPWR sky130_fd_sc_hd__decap_6
X_2198_ clknet_leaf_15_clk _0278_ VGND VGND VPWR VPWR uart_tx_raspi_inst.prescale_reg\[12\]
+ sky130_fd_sc_hd__dfxtp_1
XFILLER_0_27_3 VPWR VGND VPWR VGND sky130_ef_sc_hd__decap_12
XFILLER_0_1_51 VGND VGND VPWR VPWR sky130_fd_sc_hd__decap_4
X_2267_ clknet_leaf_28_clk _0292_ net8 VGND VGND VPWR VPWR dual_watchdog_inst.watchdog_fc.falling_edge_timeout.assert_time\[3\]
+ sky130_fd_sc_hd__dfrtp_1
X_1149_ net96 net62 VGND VGND VPWR VPWR _0014_ sky130_fd_sc_hd__xor2_1
X_1218_ net215 _0866_ _0867_ VGND VGND VPWR VPWR _0019_ sky130_fd_sc_hd__o21a_1
XFILLER_0_30_154 VPWR VGND VPWR VGND sky130_ef_sc_hd__decap_12
Xhold20 _0170_ VGND VGND VPWR VPWR net34 sky130_fd_sc_hd__dlygate4sd3_1
Xhold86 uart_tx_raspi_inst.prescale_reg\[16\] VGND VGND VPWR VPWR net100 sky130_fd_sc_hd__dlygate4sd3_1
Xhold53 _0242_ VGND VGND VPWR VPWR net67 sky130_fd_sc_hd__dlygate4sd3_1
Xhold42 _0148_ VGND VGND VPWR VPWR net56 sky130_fd_sc_hd__dlygate4sd3_1
Xhold31 dual_watchdog_inst.watchdog_fc.falling_edge_timeout.internal_count\[7\] VGND
+ VGND VPWR VPWR net45 sky130_fd_sc_hd__dlygate4sd3_1
Xhold64 dual_watchdog_inst.watchdog_fc.falling_edge_timeout.assert_time\[7\] VGND
+ VGND VPWR VPWR net78 sky130_fd_sc_hd__dlygate4sd3_1
Xhold75 dual_watchdog_inst.watchdog_fc.falling_edge_timeout.internal_count\[4\] VGND
+ VGND VPWR VPWR net89 sky130_fd_sc_hd__dlygate4sd3_1
Xhold97 dual_watchdog_inst.watchdog_fc.falling_edge_timeout.assert_time\[5\] VGND
+ VGND VPWR VPWR net111 sky130_fd_sc_hd__dlygate4sd3_1
XTAP_349 VGND VPWR sky130_fd_sc_hd__tapvpwrvgnd_1
XTAP_338 VGND VPWR sky130_fd_sc_hd__tapvpwrvgnd_1
XTAP_327 VGND VPWR sky130_fd_sc_hd__tapvpwrvgnd_1
XTAP_316 VGND VPWR sky130_fd_sc_hd__tapvpwrvgnd_1
XTAP_305 VGND VPWR sky130_fd_sc_hd__tapvpwrvgnd_1
XFILLER_0_21_154 VGND VGND VPWR VPWR sky130_fd_sc_hd__fill_1
X_2052_ clknet_leaf_9_clk _0132_ VGND VGND VPWR VPWR uart_rx_raspi_inst.bit_cnt\[3\]
+ sky130_fd_sc_hd__dfxtp_1
XFILLER_0_16_85 VGND VGND VPWR VPWR sky130_fd_sc_hd__decap_8
X_2121_ clknet_leaf_23_clk _0201_ VGND VGND VPWR VPWR uart_rx_jetson_inst.m_axis_tdata_reg\[5\]
+ sky130_fd_sc_hd__dfxtp_1
X_1905_ _0639_ VGND VGND VPWR VPWR _0099_ sky130_fd_sc_hd__inv_2
XFILLER_0_8_115 VGND VGND VPWR VPWR sky130_fd_sc_hd__fill_1
XFILLER_0_44_279 VGND VGND VPWR VPWR sky130_fd_sc_hd__decap_3
X_1767_ _0560_ VGND VGND VPWR VPWR _0075_ sky130_fd_sc_hd__inv_2
X_1836_ _0602_ _0603_ _0565_ VGND VGND VPWR VPWR _0604_ sky130_fd_sc_hd__a21oi_1
XFILLER_0_4_321 VPWR VGND VPWR VGND sky130_ef_sc_hd__decap_12
X_1698_ _0499_ _0526_ _0520_ VGND VGND VPWR VPWR _0210_ sky130_fd_sc_hd__a21oi_1
XFILLER_0_57_70 VGND VGND VPWR VPWR sky130_fd_sc_hd__decap_4
X_1621_ uart_rx_raspi_inst.data_reg\[7\] _0974_ VGND VGND VPWR VPWR _0466_ sky130_fd_sc_hd__and2_1
X_1552_ net83 _0422_ VGND VGND VPWR VPWR _0423_ sky130_fd_sc_hd__xnor2_1
XFILLER_0_1_335 VGND VGND VPWR VPWR sky130_fd_sc_hd__fill_1
X_1483_ net17 _0368_ _1009_ VGND VGND VPWR VPWR _0153_ sky130_fd_sc_hd__a21oi_1
XTAP_157 VGND VPWR sky130_fd_sc_hd__tapvpwrvgnd_1
XTAP_146 VGND VPWR sky130_fd_sc_hd__tapvpwrvgnd_1
XTAP_124 VGND VPWR sky130_fd_sc_hd__tapvpwrvgnd_1
XTAP_135 VGND VPWR sky130_fd_sc_hd__tapvpwrvgnd_1
X_2104_ clknet_leaf_22_clk _0184_ VGND VGND VPWR VPWR rst_cnt\[4\] sky130_fd_sc_hd__dfxtp_1
XTAP_168 VGND VPWR sky130_fd_sc_hd__tapvpwrvgnd_1
XTAP_179 VGND VPWR sky130_fd_sc_hd__tapvpwrvgnd_1
XFILLER_0_49_305 VGND VGND VPWR VPWR sky130_fd_sc_hd__decap_4
X_2035_ clknet_leaf_17_clk _0115_ VGND VGND VPWR VPWR uart_tx_raspi_inst.data_reg\[3\]
+ sky130_fd_sc_hd__dfxtp_1
X_1819_ _0591_ VGND VGND VPWR VPWR _0266_ sky130_fd_sc_hd__clkbuf_1
XFILLER_0_58_113 VGND VGND VPWR VPWR sky130_fd_sc_hd__fill_2
XFILLER_0_13_20 VGND VGND VPWR VPWR sky130_fd_sc_hd__decap_8
X_1604_ _0452_ net130 _0454_ VGND VGND VPWR VPWR _0455_ sky130_fd_sc_hd__mux2_1
X_1535_ _0373_ _0374_ VGND VGND VPWR VPWR _0410_ sky130_fd_sc_hd__or2_2
XFILLER_0_1_154 VPWR VGND VPWR VGND sky130_ef_sc_hd__decap_12
X_1397_ uart_rx_raspi_inst.rxd_reg _0997_ _0972_ VGND VGND VPWR VPWR _0998_ sky130_fd_sc_hd__a21o_1
X_1466_ uart_rx_raspi_inst.prescale_reg\[13\] _0349_ _0967_ VGND VGND VPWR VPWR _0359_
+ sky130_fd_sc_hd__nor3_1
XFILLER_0_54_71 VPWR VGND VPWR VGND sky130_ef_sc_hd__decap_12
XFILLER_0_49_157 VGND VGND VPWR VPWR sky130_fd_sc_hd__decap_8
XFILLER_0_49_102 VGND VGND VPWR VPWR sky130_fd_sc_hd__decap_8
XFILLER_0_9_254 VPWR VGND VPWR VGND sky130_ef_sc_hd__decap_12
X_2018_ _0709_ net187 _0703_ VGND VGND VPWR VPWR _0710_ sky130_fd_sc_hd__mux2_1
XFILLER_0_60_333 VGND VGND VPWR VPWR sky130_fd_sc_hd__decap_3
Xhold161 uart_rx_raspi_inst.data_reg\[2\] VGND VGND VPWR VPWR net175 sky130_fd_sc_hd__dlygate4sd3_1
Xhold150 uart_rx_raspi_inst.data_reg\[6\] VGND VGND VPWR VPWR net164 sky130_fd_sc_hd__dlygate4sd3_1
Xhold172 uart_tx_raspi_inst.prescale_reg\[1\] VGND VGND VPWR VPWR net186 sky130_fd_sc_hd__dlygate4sd3_1
Xhold183 uart_rx_jetson_inst.data_reg\[5\] VGND VGND VPWR VPWR net197 sky130_fd_sc_hd__dlygate4sd3_1
Xhold194 dual_watchdog_inst.watchdog_fc.falling_edge_timeout.assert_time\[24\] VGND
+ VGND VPWR VPWR net208 sky130_fd_sc_hd__dlygate4sd3_1
XFILLER_0_59_27 VPWR VGND VPWR VGND sky130_ef_sc_hd__decap_12
X_1320_ uart_tx_raspi_inst.prescale_reg\[12\] uart_tx_raspi_inst.prescale_reg\[11\]
+ _0936_ _0937_ VGND VGND VPWR VPWR _0938_ sky130_fd_sc_hd__or4_4
X_1251_ _0882_ _0886_ net131 VGND VGND VPWR VPWR _0888_ sky130_fd_sc_hd__a21oi_1
X_1182_ dual_watchdog_inst.watchdog_fc.falling_edge_timeout.internal_count\[9\] dual_watchdog_inst.watchdog_fc.falling_edge_timeout.internal_count\[8\]
+ dual_watchdog_inst.watchdog_fc.falling_edge_timeout.internal_count\[10\] dual_watchdog_inst.watchdog_fc.falling_edge_timeout.internal_count\[11\]
+ VGND VGND VPWR VPWR _0843_ sky130_fd_sc_hd__and4_1
XFILLER_0_24_63 VGND VGND VPWR VPWR sky130_fd_sc_hd__decap_6
XFILLER_0_24_85 VGND VGND VPWR VPWR sky130_fd_sc_hd__fill_2
XFILLER_0_49_60 VGND VGND VPWR VPWR sky130_fd_sc_hd__fill_2
X_1518_ _0396_ _0397_ _0379_ VGND VGND VPWR VPWR _0398_ sky130_fd_sc_hd__a21o_1
X_1449_ _0346_ _0347_ _0345_ VGND VGND VPWR VPWR _0140_ sky130_fd_sc_hd__a21oi_1
XFILLER_0_4_73 VGND VGND VPWR VPWR sky130_fd_sc_hd__decap_8
XFILLER_0_33_311 VGND VGND VPWR VPWR sky130_fd_sc_hd__decap_4
XFILLER_0_18_352 VGND VGND VPWR VPWR sky130_fd_sc_hd__decap_8
XFILLER_0_60_141 VPWR VGND VPWR VGND sky130_ef_sc_hd__decap_12
XFILLER_0_43_119 VPWR VGND VPWR VGND sky130_ef_sc_hd__decap_12
XFILLER_0_43_108 VGND VGND VPWR VPWR sky130_fd_sc_hd__decap_4
XFILLER_0_36_160 VGND VGND VPWR VPWR sky130_fd_sc_hd__decap_4
XFILLER_0_28_149 VGND VGND VPWR VPWR sky130_fd_sc_hd__decap_8
XFILLER_0_3_249 VPWR VGND VPWR VGND sky130_ef_sc_hd__decap_12
XFILLER_0_3_216 VGND VGND VPWR VPWR sky130_fd_sc_hd__decap_3
XFILLER_0_24_355 VGND VGND VPWR VPWR sky130_fd_sc_hd__decap_6
X_1303_ _0737_ _0922_ _0923_ VGND VGND VPWR VPWR _0924_ sky130_fd_sc_hd__and3_1
X_2283_ clknet_leaf_29_clk _0308_ net8 VGND VGND VPWR VPWR dual_watchdog_inst.watchdog_fc.falling_edge_timeout.assert_time\[19\]
+ sky130_fd_sc_hd__dfrtp_1
X_1234_ net97 _0875_ VGND VGND VPWR VPWR _0051_ sky130_fd_sc_hd__xor2_1
X_1096_ _0781_ VGND VGND VPWR VPWR _0237_ sky130_fd_sc_hd__clkbuf_1
X_1165_ _0832_ VGND VGND VPWR VPWR _0026_ sky130_fd_sc_hd__clkbuf_1
XFILLER_0_19_96 VGND VGND VPWR VPWR sky130_fd_sc_hd__decap_3
X_1998_ dual_watchdog_inst.watchdog_fc.falling_edge_timeout.assert_time\[25\] dual_watchdog_inst.watchdog_fc.falling_edge_timeout.assert_time\[24\]
+ _0694_ _0809_ VGND VGND VPWR VPWR _0696_ sky130_fd_sc_hd__a31o_1
XFILLER_0_18_160 VGND VGND VPWR VPWR sky130_fd_sc_hd__fill_1
XFILLER_0_18_193 VGND VGND VPWR VPWR sky130_fd_sc_hd__decap_3
XFILLER_0_56_39 VGND VGND VPWR VPWR sky130_fd_sc_hd__fill_1
XFILLER_0_56_211 VGND VGND VPWR VPWR sky130_fd_sc_hd__decap_3
X_1852_ net68 _0612_ _0589_ _1008_ VGND VGND VPWR VPWR _0615_ sky130_fd_sc_hd__a31o_1
X_1921_ dual_watchdog_inst.watchdog_fc.falling_edge_timeout.assert_time\[1\] dual_watchdog_inst.watchdog_fc.falling_edge_timeout.assert_time\[0\]
+ dual_watchdog_inst.watchdog_fc.falling_edge_timeout.assert_time\[2\] VGND VGND VPWR
+ VPWR _0642_ sky130_fd_sc_hd__a21o_1
XFILLER_0_12_358 VGND VGND VPWR VPWR sky130_fd_sc_hd__decap_4
Xfanout9 net10 VGND VGND VPWR VPWR net9 sky130_fd_sc_hd__clkbuf_2
X_1783_ net240 _0941_ net183 VGND VGND VPWR VPWR _0567_ sky130_fd_sc_hd__o21a_1
X_2266_ clknet_leaf_29_clk _0291_ net8 VGND VGND VPWR VPWR dual_watchdog_inst.watchdog_fc.falling_edge_timeout.assert_time\[2\]
+ sky130_fd_sc_hd__dfstp_1
X_1079_ dual_watchdog_inst.watchdog_fc.rising_edge_timeout.assert_time\[15\] dual_watchdog_inst.watchdog_fc.rising_edge_timeout.assert_time\[14\]
+ _0745_ dual_watchdog_inst.watchdog_fc.rising_edge_timeout.assert_time\[16\] VGND
+ VGND VPWR VPWR _0771_ sky130_fd_sc_hd__a31o_1
X_2197_ clknet_leaf_15_clk _0277_ VGND VGND VPWR VPWR uart_tx_raspi_inst.prescale_reg\[11\]
+ sky130_fd_sc_hd__dfxtp_1
X_1148_ net62 _0821_ VGND VGND VPWR VPWR _0003_ sky130_fd_sc_hd__nor2_1
X_1217_ dual_watchdog_inst.watchdog_fc.falling_edge_timeout.internal_count\[24\] _0866_
+ _0820_ VGND VGND VPWR VPWR _0867_ sky130_fd_sc_hd__a21oi_1
XFILLER_0_30_166 VGND VGND VPWR VPWR sky130_fd_sc_hd__decap_8
Xhold76 dual_watchdog_inst.watchdog_fc.rising_edge_timeout.internal_count\[13\] VGND
+ VGND VPWR VPWR net90 sky130_fd_sc_hd__dlygate4sd3_1
Xhold98 dual_watchdog_inst.watchdog_fc.rising_edge_timeout.internal_count\[18\] VGND
+ VGND VPWR VPWR net112 sky130_fd_sc_hd__dlygate4sd3_1
Xhold65 uart_tx_jetson_inst.prescale_reg\[16\] VGND VGND VPWR VPWR net79 sky130_fd_sc_hd__dlygate4sd3_1
Xhold87 _0282_ VGND VGND VPWR VPWR net101 sky130_fd_sc_hd__dlygate4sd3_1
Xhold54 uart_tx_raspi_inst.prescale_reg\[10\] VGND VGND VPWR VPWR net68 sky130_fd_sc_hd__dlygate4sd3_1
Xhold21 uart_rx_raspi_inst.prescale_reg\[7\] VGND VGND VPWR VPWR net35 sky130_fd_sc_hd__dlygate4sd3_1
Xhold43 rst_cnt\[3\] VGND VGND VPWR VPWR net57 sky130_fd_sc_hd__dlygate4sd3_1
Xhold10 _0186_ VGND VGND VPWR VPWR net24 sky130_fd_sc_hd__dlygate4sd3_1
Xhold32 uart_rx_jetson_inst.prescale_reg\[17\] VGND VGND VPWR VPWR net46 sky130_fd_sc_hd__dlygate4sd3_1
XFILLER_0_53_269 VGND VGND VPWR VPWR sky130_fd_sc_hd__fill_2
XFILLER_0_21_111 VGND VGND VPWR VPWR sky130_fd_sc_hd__fill_1
XFILLER_0_21_122 VPWR VGND VPWR VGND sky130_ef_sc_hd__decap_12
XTAP_339 VGND VPWR sky130_fd_sc_hd__tapvpwrvgnd_1
XTAP_328 VGND VPWR sky130_fd_sc_hd__tapvpwrvgnd_1
XTAP_317 VGND VPWR sky130_fd_sc_hd__tapvpwrvgnd_1
XTAP_306 VGND VPWR sky130_fd_sc_hd__tapvpwrvgnd_1
X_2120_ clknet_leaf_23_clk _0200_ VGND VGND VPWR VPWR uart_rx_jetson_inst.m_axis_tdata_reg\[4\]
+ sky130_fd_sc_hd__dfxtp_1
X_2051_ clknet_leaf_16_clk _0131_ VGND VGND VPWR VPWR uart_rx_raspi_inst.bit_cnt\[2\]
+ sky130_fd_sc_hd__dfxtp_1
X_1904_ _0639_ VGND VGND VPWR VPWR _0098_ sky130_fd_sc_hd__inv_2
XFILLER_0_32_85 VGND VGND VPWR VPWR sky130_fd_sc_hd__fill_2
X_1835_ uart_tx_raspi_inst.prescale_reg\[4\] _0933_ uart_tx_raspi_inst.prescale_reg\[5\]
+ VGND VGND VPWR VPWR _0603_ sky130_fd_sc_hd__o21ai_1
XFILLER_0_4_333 VPWR VGND VPWR VGND sky130_ef_sc_hd__decap_12
XFILLER_0_8_105 VGND VGND VPWR VPWR sky130_fd_sc_hd__fill_2
XFILLER_0_8_149 VPWR VGND VPWR VGND sky130_ef_sc_hd__decap_12
X_1766_ _0560_ VGND VGND VPWR VPWR _0074_ sky130_fd_sc_hd__inv_2
X_1697_ _0524_ _0525_ _0504_ VGND VGND VPWR VPWR _0526_ sky130_fd_sc_hd__a21o_1
X_2249_ clknet_leaf_5_clk _0033_ _0096_ VGND VGND VPWR VPWR dual_watchdog_inst.watchdog_fc.rising_edge_timeout.internal_count\[12\]
+ sky130_fd_sc_hd__dfrtp_1
XFILLER_0_50_206 VGND VGND VPWR VPWR sky130_fd_sc_hd__decap_8
XFILLER_0_35_225 VGND VGND VPWR VPWR sky130_fd_sc_hd__decap_6
XFILLER_0_7_160 VGND VGND VPWR VPWR sky130_fd_sc_hd__decap_4
XFILLER_0_9_3 VGND VGND VPWR VPWR sky130_fd_sc_hd__decap_4
X_1620_ _0465_ VGND VGND VPWR VPWR _0193_ sky130_fd_sc_hd__clkbuf_1
X_1551_ uart_tx_jetson_inst.prescale_reg\[10\] _0417_ VGND VGND VPWR VPWR _0422_ sky130_fd_sc_hd__nor2_1
X_1482_ net188 uart_rx_raspi_inst.m_axis_tvalid_reg VGND VGND VPWR VPWR _0368_ sky130_fd_sc_hd__or2b_1
XTAP_158 VGND VPWR sky130_fd_sc_hd__tapvpwrvgnd_1
X_2103_ clknet_leaf_22_clk _0183_ VGND VGND VPWR VPWR rst_cnt\[3\] sky130_fd_sc_hd__dfxtp_1
XTAP_147 VGND VPWR sky130_fd_sc_hd__tapvpwrvgnd_1
XTAP_125 VGND VPWR sky130_fd_sc_hd__tapvpwrvgnd_1
XTAP_136 VGND VPWR sky130_fd_sc_hd__tapvpwrvgnd_1
XTAP_169 VGND VPWR sky130_fd_sc_hd__tapvpwrvgnd_1
XFILLER_0_57_361 VGND VGND VPWR VPWR sky130_fd_sc_hd__fill_1
XFILLER_0_49_328 VGND VGND VPWR VPWR sky130_fd_sc_hd__decap_4
X_2034_ clknet_leaf_17_clk _0114_ VGND VGND VPWR VPWR uart_tx_raspi_inst.data_reg\[2\]
+ sky130_fd_sc_hd__dfxtp_1
X_1818_ _0964_ _0590_ VGND VGND VPWR VPWR _0591_ sky130_fd_sc_hd__and2b_1
XFILLER_0_4_141 VGND VGND VPWR VPWR sky130_fd_sc_hd__fill_2
X_1749_ _0559_ VGND VGND VPWR VPWR _0058_ sky130_fd_sc_hd__inv_2
XFILLER_0_7_73 VGND VGND VPWR VPWR sky130_fd_sc_hd__decap_3
XFILLER_0_7_40 VGND VGND VPWR VPWR sky130_fd_sc_hd__fill_1
XFILLER_0_48_350 VPWR VGND VPWR VGND sky130_ef_sc_hd__decap_12
XFILLER_0_31_261 VPWR VGND VPWR VGND sky130_ef_sc_hd__decap_12
XFILLER_0_16_291 VGND VGND VPWR VPWR sky130_fd_sc_hd__fill_1
XFILLER_0_23_239 VGND VGND VPWR VPWR sky130_fd_sc_hd__decap_3
XFILLER_0_46_309 VPWR VGND VPWR VGND sky130_ef_sc_hd__decap_12
XFILLER_0_39_361 VGND VGND VPWR VPWR sky130_fd_sc_hd__fill_1
XFILLER_0_14_239 VGND VGND VPWR VPWR sky130_fd_sc_hd__decap_3
X_1534_ _0409_ VGND VGND VPWR VPWR _0163_ sky130_fd_sc_hd__clkbuf_1
X_1603_ _0453_ VGND VGND VPWR VPWR _0454_ sky130_fd_sc_hd__buf_6
X_1465_ _0345_ net129 VGND VGND VPWR VPWR _0145_ sky130_fd_sc_hd__nor2_1
XFILLER_0_1_111 VGND VGND VPWR VPWR sky130_fd_sc_hd__fill_1
XFILLER_0_1_166 VGND VGND VPWR VPWR sky130_fd_sc_hd__fill_2
XFILLER_0_54_83 VGND VGND VPWR VPWR sky130_fd_sc_hd__fill_1
X_1396_ uart_rx_raspi_inst.bit_cnt\[2\] uart_rx_raspi_inst.bit_cnt\[1\] uart_rx_raspi_inst.bit_cnt\[3\]
+ VGND VGND VPWR VPWR _0997_ sky130_fd_sc_hd__o21a_1
X_2017_ uart_rx_jetson_inst.data_reg\[4\] _0501_ VGND VGND VPWR VPWR _0709_ sky130_fd_sc_hd__and2_1
XFILLER_0_57_180 VGND VGND VPWR VPWR sky130_fd_sc_hd__decap_6
XFILLER_0_49_169 VGND VGND VPWR VPWR sky130_fd_sc_hd__decap_6
Xhold140 uart_tx_jetson_inst.data_reg\[4\] VGND VGND VPWR VPWR net154 sky130_fd_sc_hd__dlygate4sd3_1
Xhold162 uart_tx_raspi_inst.data_reg\[1\] VGND VGND VPWR VPWR net176 sky130_fd_sc_hd__dlygate4sd3_1
Xhold151 uart_tx_raspi_inst.data_reg\[0\] VGND VGND VPWR VPWR net165 sky130_fd_sc_hd__dlygate4sd3_1
Xhold184 uart_tx_jetson_inst.prescale_reg\[18\] VGND VGND VPWR VPWR net198 sky130_fd_sc_hd__dlygate4sd3_1
Xhold195 uart_rx_raspi_inst.prescale_reg\[0\] VGND VGND VPWR VPWR net209 sky130_fd_sc_hd__dlygate4sd3_1
Xhold173 uart_rx_jetson_inst.data_reg\[3\] VGND VGND VPWR VPWR net187 sky130_fd_sc_hd__dlygate4sd3_1
XFILLER_0_28_309 VGND VGND VPWR VPWR sky130_fd_sc_hd__decap_6
XFILLER_0_36_320 VGND VGND VPWR VPWR sky130_fd_sc_hd__decap_4
XFILLER_0_59_39 VGND VGND VPWR VPWR sky130_fd_sc_hd__decap_8
X_1250_ dual_watchdog_inst.watchdog_fc.rising_edge_timeout.internal_count\[10\] _0882_
+ _0886_ VGND VGND VPWR VPWR _0887_ sky130_fd_sc_hd__and3_1
X_1181_ _0797_ _0840_ _0842_ _0841_ VGND VGND VPWR VPWR _0006_ sky130_fd_sc_hd__o211a_1
XFILLER_0_42_356 VGND VGND VPWR VPWR sky130_fd_sc_hd__decap_6
XFILLER_0_49_72 VGND VGND VPWR VPWR sky130_fd_sc_hd__fill_2
X_1517_ uart_tx_jetson_inst.prescale_reg\[1\] uart_tx_jetson_inst.prescale_reg\[0\]
+ uart_tx_jetson_inst.prescale_reg\[2\] VGND VGND VPWR VPWR _0397_ sky130_fd_sc_hd__o21ai_1
X_1448_ net35 _0966_ VGND VGND VPWR VPWR _0347_ sky130_fd_sc_hd__nand2_1
XFILLER_0_10_253 VGND VGND VPWR VPWR sky130_fd_sc_hd__decap_8
XFILLER_0_10_297 VGND VGND VPWR VPWR sky130_fd_sc_hd__decap_8
X_1379_ _0964_ _0984_ VGND VGND VPWR VPWR _0985_ sky130_fd_sc_hd__and2b_1
XFILLER_0_33_323 VGND VGND VPWR VPWR sky130_fd_sc_hd__decap_3
XFILLER_0_60_197 VPWR VGND VPWR VGND sky130_ef_sc_hd__decap_12
XFILLER_0_60_153 VPWR VGND VPWR VGND sky130_ef_sc_hd__decap_12
XFILLER_0_10_66 VGND VGND VPWR VPWR sky130_fd_sc_hd__fill_1
X_1302_ dual_watchdog_inst.watchdog_fc.rising_edge_timeout.internal_count\[25\] dual_watchdog_inst.watchdog_fc.rising_edge_timeout.internal_count\[24\]
+ dual_watchdog_inst.watchdog_fc.rising_edge_timeout.internal_count\[26\] _0919_ VGND
+ VGND VPWR VPWR _0923_ sky130_fd_sc_hd__nand4_1
X_1233_ _0875_ _0876_ VGND VGND VPWR VPWR _0050_ sky130_fd_sc_hd__nor2_1
X_2282_ clknet_leaf_28_clk _0307_ net8 VGND VGND VPWR VPWR dual_watchdog_inst.watchdog_fc.falling_edge_timeout.assert_time\[18\]
+ sky130_fd_sc_hd__dfrtp_1
XFILLER_0_19_20 VGND VGND VPWR VPWR sky130_fd_sc_hd__decap_6
X_1095_ _0743_ _0766_ _0780_ VGND VGND VPWR VPWR _0781_ sky130_fd_sc_hd__and3b_1
X_1164_ _0829_ _0830_ _0831_ VGND VGND VPWR VPWR _0832_ sky130_fd_sc_hd__and3_1
XFILLER_0_27_183 VGND VGND VPWR VPWR sky130_fd_sc_hd__decap_8
XFILLER_0_19_117 VGND VGND VPWR VPWR sky130_fd_sc_hd__fill_2
X_1997_ net208 _0694_ _0695_ VGND VGND VPWR VPWR _0313_ sky130_fd_sc_hd__o21a_1
XFILLER_0_42_197 VGND VGND VPWR VPWR sky130_fd_sc_hd__fill_1
XFILLER_0_2_250 VGND VGND VPWR VPWR sky130_fd_sc_hd__fill_2
XFILLER_0_33_120 VGND VGND VPWR VPWR sky130_fd_sc_hd__fill_1
XFILLER_0_0_209 VPWR VGND VPWR VGND sky130_ef_sc_hd__decap_12
XFILLER_0_21_337 VGND VGND VPWR VPWR sky130_fd_sc_hd__fill_1
XFILLER_0_56_29 VGND VGND VPWR VPWR sky130_fd_sc_hd__decap_6
XFILLER_0_56_256 VGND VGND VPWR VPWR sky130_fd_sc_hd__decap_3
X_1851_ _0612_ _0589_ net68 VGND VGND VPWR VPWR _0614_ sky130_fd_sc_hd__a21oi_1
X_1920_ _0641_ VGND VGND VPWR VPWR _0290_ sky130_fd_sc_hd__clkbuf_1
XFILLER_0_12_304 VGND VGND VPWR VPWR sky130_fd_sc_hd__decap_4
X_1782_ net165 _0942_ VGND VGND VPWR VPWR _0566_ sky130_fd_sc_hd__or2_1
XFILLER_0_24_197 VGND VGND VPWR VPWR sky130_fd_sc_hd__decap_8
X_2196_ clknet_leaf_16_clk _0276_ VGND VGND VPWR VPWR uart_tx_raspi_inst.prescale_reg\[10\]
+ sky130_fd_sc_hd__dfxtp_1
X_2265_ clknet_leaf_29_clk _0290_ net8 VGND VGND VPWR VPWR dual_watchdog_inst.watchdog_fc.falling_edge_timeout.assert_time\[1\]
+ sky130_fd_sc_hd__dfrtp_2
X_1216_ _0863_ _0861_ _0866_ VGND VGND VPWR VPWR _0018_ sky130_fd_sc_hd__a21oi_1
XFILLER_0_47_245 VGND VGND VPWR VPWR sky130_fd_sc_hd__fill_1
X_1078_ net98 _0747_ _0770_ VGND VGND VPWR VPWR _0244_ sky130_fd_sc_hd__o21a_1
X_1147_ _0820_ VGND VGND VPWR VPWR _0821_ sky130_fd_sc_hd__clkbuf_4
Xhold11 dual_watchdog_inst.watchdog_fc.rising_edge_timeout.assert_time\[0\] VGND VGND
+ VPWR VPWR net25 sky130_fd_sc_hd__dlygate4sd3_1
Xhold22 uart_rx_jetson_inst.prescale_reg\[8\] VGND VGND VPWR VPWR net36 sky130_fd_sc_hd__dlygate4sd3_1
XFILLER_0_15_197 VGND VGND VPWR VPWR sky130_fd_sc_hd__decap_4
Xhold44 uart_tx_jetson_inst.prescale_reg\[1\] VGND VGND VPWR VPWR net58 sky130_fd_sc_hd__dlygate4sd3_1
Xhold66 uart_tx_raspi_inst.prescale_reg\[8\] VGND VGND VPWR VPWR net80 sky130_fd_sc_hd__dlygate4sd3_1
Xhold88 uart_rx_raspi_inst.prescale_reg\[14\] VGND VGND VPWR VPWR net102 sky130_fd_sc_hd__dlygate4sd3_1
Xhold77 dual_watchdog_inst.watchdog_fc.falling_edge_timeout.internal_count\[3\] VGND
+ VGND VPWR VPWR net91 sky130_fd_sc_hd__dlygate4sd3_1
Xhold33 _0556_ VGND VGND VPWR VPWR net47 sky130_fd_sc_hd__dlygate4sd3_1
Xhold55 uart_rx_jetson_inst.prescale_reg\[16\] VGND VGND VPWR VPWR net69 sky130_fd_sc_hd__dlygate4sd3_1
Xhold99 uart_tx_raspi_inst.bit_cnt\[2\] VGND VGND VPWR VPWR net113 sky130_fd_sc_hd__dlygate4sd3_1
XFILLER_0_21_134 VGND VGND VPWR VPWR sky130_fd_sc_hd__decap_8
XFILLER_0_21_189 VGND VGND VPWR VPWR sky130_fd_sc_hd__decap_8
XTAP_329 VGND VPWR sky130_fd_sc_hd__tapvpwrvgnd_1
X_2050_ clknet_leaf_9_clk _0130_ VGND VGND VPWR VPWR uart_rx_raspi_inst.bit_cnt\[1\]
+ sky130_fd_sc_hd__dfxtp_1
XTAP_318 VGND VPWR sky130_fd_sc_hd__tapvpwrvgnd_1
XTAP_307 VGND VPWR sky130_fd_sc_hd__tapvpwrvgnd_1
XFILLER_0_29_212 VGND VGND VPWR VPWR sky130_fd_sc_hd__decap_8
XFILLER_0_16_76 VGND VGND VPWR VPWR sky130_fd_sc_hd__decap_8
X_1903_ _0639_ VGND VGND VPWR VPWR _0097_ sky130_fd_sc_hd__inv_2
XFILLER_0_44_259 VGND VGND VPWR VPWR sky130_fd_sc_hd__fill_1
X_1765_ _0560_ VGND VGND VPWR VPWR _0073_ sky130_fd_sc_hd__inv_2
X_1834_ uart_tx_raspi_inst.prescale_reg\[5\] uart_tx_raspi_inst.prescale_reg\[4\]
+ _0933_ VGND VGND VPWR VPWR _0602_ sky130_fd_sc_hd__or3_2
XFILLER_0_4_345 VPWR VGND VPWR VGND sky130_ef_sc_hd__decap_12
X_1696_ uart_rx_jetson_inst.prescale_reg\[2\] _0521_ VGND VGND VPWR VPWR _0525_ sky130_fd_sc_hd__nand2_1
XFILLER_0_12_134 VGND VGND VPWR VPWR sky130_fd_sc_hd__decap_6
XFILLER_0_12_167 VGND VGND VPWR VPWR sky130_fd_sc_hd__fill_1
X_2179_ clknet_leaf_11_clk _0259_ VGND VGND VPWR VPWR uart_tx_jetson_inst.data_reg\[2\]
+ sky130_fd_sc_hd__dfxtp_1
X_2248_ clknet_leaf_4_clk _0032_ _0095_ VGND VGND VPWR VPWR dual_watchdog_inst.watchdog_fc.rising_edge_timeout.internal_count\[11\]
+ sky130_fd_sc_hd__dfrtp_1
XFILLER_0_32_3 VPWR VGND VPWR VGND sky130_ef_sc_hd__decap_12
XFILLER_0_43_281 VGND VGND VPWR VPWR sky130_fd_sc_hd__decap_6
XFILLER_0_58_307 VGND VGND VPWR VPWR sky130_fd_sc_hd__fill_1
XFILLER_0_26_226 VGND VGND VPWR VPWR sky130_fd_sc_hd__decap_3
X_1550_ _0421_ VGND VGND VPWR VPWR _0167_ sky130_fd_sc_hd__clkbuf_1
XTAP_148 VGND VPWR sky130_fd_sc_hd__tapvpwrvgnd_1
XTAP_126 VGND VPWR sky130_fd_sc_hd__tapvpwrvgnd_1
XTAP_137 VGND VPWR sky130_fd_sc_hd__tapvpwrvgnd_1
XFILLER_0_1_337 VPWR VGND VPWR VGND sky130_ef_sc_hd__decap_12
X_1481_ _0367_ VGND VGND VPWR VPWR _0152_ sky130_fd_sc_hd__clkbuf_1
X_2033_ clknet_leaf_17_clk _0113_ VGND VGND VPWR VPWR uart_tx_raspi_inst.data_reg\[1\]
+ sky130_fd_sc_hd__dfxtp_1
XFILLER_0_27_53 VGND VGND VPWR VPWR sky130_fd_sc_hd__decap_3
X_2102_ clknet_leaf_22_clk _0182_ VGND VGND VPWR VPWR rst_cnt\[2\] sky130_fd_sc_hd__dfxtp_1
XTAP_159 VGND VPWR sky130_fd_sc_hd__tapvpwrvgnd_1
XFILLER_0_43_96 VPWR VGND VPWR VGND sky130_ef_sc_hd__decap_12
XFILLER_0_40_251 VGND VGND VPWR VPWR sky130_fd_sc_hd__fill_1
XFILLER_0_40_240 VGND VGND VPWR VPWR sky130_fd_sc_hd__decap_4
X_1748_ _0559_ VGND VGND VPWR VPWR _0057_ sky130_fd_sc_hd__inv_2
X_1817_ _0588_ _0943_ _0589_ VGND VGND VPWR VPWR _0590_ sky130_fd_sc_hd__o21a_1
XFILLER_0_4_197 VGND VGND VPWR VPWR sky130_fd_sc_hd__decap_8
XFILLER_0_7_96 VPWR VGND VPWR VGND sky130_ef_sc_hd__decap_12
X_1679_ _0510_ _0511_ VGND VGND VPWR VPWR _0512_ sky130_fd_sc_hd__nand2_1
XFILLER_0_31_273 VGND VGND VPWR VPWR sky130_fd_sc_hd__decap_6
XFILLER_0_31_251 VGND VGND VPWR VPWR sky130_fd_sc_hd__fill_1
XFILLER_0_13_11 VGND VGND VPWR VPWR sky130_fd_sc_hd__fill_2
X_1602_ uart_rst _0972_ _0997_ _0327_ VGND VGND VPWR VPWR _0453_ sky130_fd_sc_hd__or4_4
XFILLER_0_14_207 VGND VGND VPWR VPWR sky130_fd_sc_hd__decap_8
X_1533_ _0964_ _0389_ _0408_ VGND VGND VPWR VPWR _0409_ sky130_fd_sc_hd__and3b_1
X_1395_ uart_rx_raspi_inst.bit_cnt\[0\] _0973_ VGND VGND VPWR VPWR _0996_ sky130_fd_sc_hd__nor2_1
X_1464_ _0349_ _0967_ _0357_ VGND VGND VPWR VPWR _0358_ sky130_fd_sc_hd__o21a_1
XFILLER_0_22_284 VGND VGND VPWR VPWR sky130_fd_sc_hd__fill_1
X_2016_ _0708_ VGND VGND VPWR VPWR _0318_ sky130_fd_sc_hd__clkbuf_1
Xclkbuf_leaf_30_clk clknet_2_0__leaf_clk VGND VGND VPWR VPWR clknet_leaf_30_clk sky130_fd_sc_hd__clkbuf_16
Xhold174 uart_tx_jetson_inst.s_axis_tready_reg VGND VGND VPWR VPWR net188 sky130_fd_sc_hd__dlygate4sd3_1
Xhold141 uart_rx_jetson_inst.data_reg\[0\] VGND VGND VPWR VPWR net155 sky130_fd_sc_hd__dlygate4sd3_1
Xhold152 dual_watchdog_inst.watchdog_fc.rising_edge_timeout.assert_time\[8\] VGND
+ VGND VPWR VPWR net166 sky130_fd_sc_hd__dlygate4sd3_1
Xhold163 dual_watchdog_inst.watchdog_fc.rising_edge_timeout.assert_time\[5\] VGND
+ VGND VPWR VPWR net177 sky130_fd_sc_hd__dlygate4sd3_1
Xhold185 dual_watchdog_inst.watchdog_fc.falling_edge_timeout.assert_time\[13\] VGND
+ VGND VPWR VPWR net199 sky130_fd_sc_hd__dlygate4sd3_1
XFILLER_0_13_273 VGND VGND VPWR VPWR sky130_fd_sc_hd__fill_1
Xhold130 _0020_ VGND VGND VPWR VPWR net144 sky130_fd_sc_hd__dlygate4sd3_1
XTAP_490 VGND VPWR sky130_fd_sc_hd__tapvpwrvgnd_1
Xhold196 uart_rx_jetson_inst.prescale_reg\[18\] VGND VGND VPWR VPWR net210 sky130_fd_sc_hd__dlygate4sd3_1
Xclkbuf_leaf_21_clk clknet_2_2__leaf_clk VGND VGND VPWR VPWR clknet_leaf_21_clk sky130_fd_sc_hd__clkbuf_16
X_1180_ _0797_ _0840_ VGND VGND VPWR VPWR _0842_ sky130_fd_sc_hd__nand2_1
Xclkbuf_leaf_12_clk clknet_2_3__leaf_clk VGND VGND VPWR VPWR clknet_leaf_12_clk sky130_fd_sc_hd__clkbuf_16
XFILLER_0_54_195 VGND VGND VPWR VPWR sky130_fd_sc_hd__fill_1
X_1516_ uart_tx_jetson_inst.prescale_reg\[2\] uart_tx_jetson_inst.prescale_reg\[1\]
+ uart_tx_jetson_inst.prescale_reg\[0\] VGND VGND VPWR VPWR _0396_ sky130_fd_sc_hd__or3_1
X_1378_ uart_rx_raspi_inst.data_reg\[3\] uart_rx_raspi_inst.m_axis_tdata_reg\[3\]
+ _0977_ VGND VGND VPWR VPWR _0984_ sky130_fd_sc_hd__mux2_1
XFILLER_0_49_84 VGND VGND VPWR VPWR sky130_fd_sc_hd__fill_1
X_1447_ uart_rx_raspi_inst.prescale_reg\[7\] _0966_ VGND VGND VPWR VPWR _0346_ sky130_fd_sc_hd__or2_1
XFILLER_0_4_20 VGND VGND VPWR VPWR sky130_fd_sc_hd__fill_2
XFILLER_0_60_165 VGND VGND VPWR VPWR sky130_fd_sc_hd__decap_3
XFILLER_0_60_121 VPWR VGND VPWR VGND sky130_ef_sc_hd__decap_12
XFILLER_0_18_321 VGND VGND VPWR VPWR sky130_fd_sc_hd__decap_8
XFILLER_0_36_195 VGND VGND VPWR VPWR sky130_fd_sc_hd__fill_1
X_1301_ dual_watchdog_inst.watchdog_fc.rising_edge_timeout.internal_count\[25\] dual_watchdog_inst.watchdog_fc.rising_edge_timeout.internal_count\[24\]
+ _0919_ dual_watchdog_inst.watchdog_fc.rising_edge_timeout.internal_count\[26\] VGND
+ VGND VPWR VPWR _0922_ sky130_fd_sc_hd__a31o_1
X_1232_ net85 _0872_ VGND VGND VPWR VPWR _0876_ sky130_fd_sc_hd__nor2_1
Xclkbuf_leaf_1_clk clknet_2_1__leaf_clk VGND VGND VPWR VPWR clknet_leaf_1_clk sky130_fd_sc_hd__clkbuf_16
X_2281_ clknet_leaf_27_clk _0306_ net9 VGND VGND VPWR VPWR dual_watchdog_inst.watchdog_fc.falling_edge_timeout.assert_time\[17\]
+ sky130_fd_sc_hd__dfrtp_1
XFILLER_0_19_65 VGND VGND VPWR VPWR sky130_fd_sc_hd__fill_1
XFILLER_0_35_86 VPWR VGND VPWR VGND sky130_ef_sc_hd__decap_12
X_1094_ dual_watchdog_inst.watchdog_fc.rising_edge_timeout.assert_time\[9\] dual_watchdog_inst.watchdog_fc.rising_edge_timeout.assert_time\[8\]
+ _0742_ dual_watchdog_inst.watchdog_fc.rising_edge_timeout.assert_time\[10\] VGND
+ VGND VPWR VPWR _0780_ sky130_fd_sc_hd__a31o_1
XFILLER_0_29_9 VGND VGND VPWR VPWR sky130_fd_sc_hd__fill_1
X_1163_ dual_watchdog_inst.watchdog_fc.falling_edge_timeout.internal_count\[6\] _0825_
+ _0827_ VGND VGND VPWR VPWR _0831_ sky130_fd_sc_hd__nand3_1
XFILLER_0_42_110 VPWR VGND VPWR VGND sky130_ef_sc_hd__decap_12
X_1996_ dual_watchdog_inst.watchdog_fc.falling_edge_timeout.assert_time\[24\] _0694_
+ _0820_ VGND VGND VPWR VPWR _0695_ sky130_fd_sc_hd__a21oi_1
XFILLER_0_56_19 VGND VGND VPWR VPWR sky130_fd_sc_hd__fill_1
XFILLER_0_56_279 VPWR VGND VPWR VGND sky130_ef_sc_hd__decap_12
X_1781_ uart_tx_raspi_inst.prescale_reg\[18\] _0564_ VGND VGND VPWR VPWR _0565_ sky130_fd_sc_hd__nor2_1
X_1850_ _0612_ _0613_ _0609_ VGND VGND VPWR VPWR _0275_ sky130_fd_sc_hd__o21ba_1
XFILLER_0_21_77 VGND VGND VPWR VPWR sky130_fd_sc_hd__decap_8
XFILLER_0_20_360 VGND VGND VPWR VPWR sky130_fd_sc_hd__fill_2
XFILLER_0_46_85 VGND VGND VPWR VPWR sky130_fd_sc_hd__decap_4
X_2195_ clknet_leaf_15_clk _0275_ VGND VGND VPWR VPWR uart_tx_raspi_inst.prescale_reg\[9\]
+ sky130_fd_sc_hd__dfxtp_1
X_1146_ _0809_ VGND VGND VPWR VPWR _0820_ sky130_fd_sc_hd__clkbuf_4
X_2264_ clknet_leaf_29_clk _0289_ net8 VGND VGND VPWR VPWR dual_watchdog_inst.watchdog_fc.falling_edge_timeout.assert_time\[0\]
+ sky130_fd_sc_hd__dfstp_2
X_1215_ _0865_ VGND VGND VPWR VPWR _0866_ sky130_fd_sc_hd__clkbuf_2
X_1077_ net179 _0747_ _0764_ VGND VGND VPWR VPWR _0770_ sky130_fd_sc_hd__a21oi_1
X_1979_ _0682_ VGND VGND VPWR VPWR _0683_ sky130_fd_sc_hd__inv_2
XFILLER_0_15_176 VGND VGND VPWR VPWR sky130_fd_sc_hd__fill_1
Xhold56 uart_tx_jetson_inst.prescale_reg\[15\] VGND VGND VPWR VPWR net70 sky130_fd_sc_hd__dlygate4sd3_1
Xhold12 uart_tx_raspi_inst.prescale_reg\[15\] VGND VGND VPWR VPWR net26 sky130_fd_sc_hd__dlygate4sd3_1
XFILLER_0_11_360 VGND VGND VPWR VPWR sky130_fd_sc_hd__fill_2
Xhold34 _0225_ VGND VGND VPWR VPWR net48 sky130_fd_sc_hd__dlygate4sd3_1
Xhold45 uart_tx_raspi_inst.bit_cnt\[1\] VGND VGND VPWR VPWR net59 sky130_fd_sc_hd__dlygate4sd3_1
Xhold23 uart_tx_raspi_inst.s_axis_tready_reg VGND VGND VPWR VPWR net37 sky130_fd_sc_hd__dlygate4sd3_1
Xhold78 uart_tx_raspi_inst.prescale_reg\[12\] VGND VGND VPWR VPWR net92 sky130_fd_sc_hd__dlygate4sd3_1
Xhold67 uart_rx_raspi_inst.prescale_reg\[16\] VGND VGND VPWR VPWR net81 sky130_fd_sc_hd__dlygate4sd3_1
Xhold89 dual_watchdog_inst.watchdog_fc.falling_edge_timeout.internal_count\[2\] VGND
+ VGND VPWR VPWR net103 sky130_fd_sc_hd__dlygate4sd3_1
XTAP_319 VGND VPWR sky130_fd_sc_hd__tapvpwrvgnd_1
XTAP_308 VGND VPWR sky130_fd_sc_hd__tapvpwrvgnd_1
XFILLER_0_21_102 VGND VGND VPWR VPWR sky130_fd_sc_hd__fill_1
X_1902_ _0558_ VGND VGND VPWR VPWR _0639_ sky130_fd_sc_hd__buf_4
XFILLER_0_29_235 VGND VGND VPWR VPWR sky130_fd_sc_hd__fill_1
XFILLER_0_16_99 VGND VGND VPWR VPWR sky130_fd_sc_hd__decap_4
X_1764_ _0560_ VGND VGND VPWR VPWR _0072_ sky130_fd_sc_hd__inv_2
X_1833_ _0601_ VGND VGND VPWR VPWR _0270_ sky130_fd_sc_hd__clkbuf_1
XFILLER_0_4_357 VGND VGND VPWR VPWR sky130_fd_sc_hd__decap_4
XFILLER_0_57_62 VGND VGND VPWR VPWR sky130_fd_sc_hd__fill_1
X_1695_ uart_rx_jetson_inst.prescale_reg\[2\] _0521_ VGND VGND VPWR VPWR _0524_ sky130_fd_sc_hd__or2_1
X_2178_ clknet_leaf_11_clk _0258_ VGND VGND VPWR VPWR uart_tx_jetson_inst.data_reg\[1\]
+ sky130_fd_sc_hd__dfxtp_1
X_2247_ clknet_leaf_4_clk _0031_ _0094_ VGND VGND VPWR VPWR dual_watchdog_inst.watchdog_fc.rising_edge_timeout.internal_count\[10\]
+ sky130_fd_sc_hd__dfrtp_1
X_1129_ dual_watchdog_inst.watchdog_fc.falling_edge_timeout.internal_count\[17\] dual_watchdog_inst.watchdog_fc.falling_edge_timeout.internal_count\[16\]
+ VGND VGND VPWR VPWR _0804_ sky130_fd_sc_hd__and2_1
XFILLER_0_25_3 VPWR VGND VPWR VGND sky130_ef_sc_hd__decap_12
XFILLER_0_7_151 VGND VGND VPWR VPWR sky130_fd_sc_hd__fill_1
XFILLER_0_43_260 VPWR VGND VPWR VGND sky130_ef_sc_hd__decap_12
XFILLER_0_1_305 VPWR VGND VPWR VGND sky130_ef_sc_hd__decap_12
XTAP_149 VGND VPWR sky130_fd_sc_hd__tapvpwrvgnd_1
XTAP_127 VGND VPWR sky130_fd_sc_hd__tapvpwrvgnd_1
XTAP_138 VGND VPWR sky130_fd_sc_hd__tapvpwrvgnd_1
XFILLER_0_1_349 VPWR VGND VPWR VGND sky130_ef_sc_hd__decap_12
X_1480_ _1008_ net2 VGND VGND VPWR VPWR _0367_ sky130_fd_sc_hd__or2_1
X_2032_ clknet_leaf_17_clk _0112_ VGND VGND VPWR VPWR uart_tx_raspi_inst.data_reg\[0\]
+ sky130_fd_sc_hd__dfxtp_1
X_2101_ clknet_leaf_22_clk _0181_ VGND VGND VPWR VPWR rst_cnt\[1\] sky130_fd_sc_hd__dfxtp_1
X_1747_ _0558_ VGND VGND VPWR VPWR _0559_ sky130_fd_sc_hd__buf_4
XFILLER_0_4_176 VPWR VGND VPWR VGND sky130_ef_sc_hd__decap_12
X_1678_ uart_rx_jetson_inst.bit_cnt\[2\] _0477_ VGND VGND VPWR VPWR _0511_ sky130_fd_sc_hd__nand2_1
X_1816_ uart_rx_jetson_inst.m_axis_tvalid_reg _0940_ _0929_ VGND VGND VPWR VPWR _0589_
+ sky130_fd_sc_hd__or3_2
XFILLER_0_48_341 VGND VGND VPWR VPWR sky130_fd_sc_hd__fill_1
X_1601_ uart_rx_raspi_inst.data_reg\[1\] _0974_ VGND VGND VPWR VPWR _0452_ sky130_fd_sc_hd__and2_1
X_1532_ uart_tx_jetson_inst.prescale_reg\[6\] _0405_ VGND VGND VPWR VPWR _0408_ sky130_fd_sc_hd__xnor2_1
XFILLER_0_1_113 VGND VGND VPWR VPWR sky130_fd_sc_hd__fill_1
X_1394_ net150 VGND VGND VPWR VPWR _0995_ sky130_fd_sc_hd__inv_2
X_1463_ net128 _0355_ VGND VGND VPWR VPWR _0357_ sky130_fd_sc_hd__nand2_1
X_2015_ _0707_ net184 _0703_ VGND VGND VPWR VPWR _0708_ sky130_fd_sc_hd__mux2_1
XFILLER_0_45_322 VPWR VGND VPWR VGND sky130_ef_sc_hd__decap_12
XFILLER_0_9_279 VGND VGND VPWR VPWR sky130_fd_sc_hd__fill_1
Xhold175 uart_rx_raspi_inst.data_reg\[3\] VGND VGND VPWR VPWR net189 sky130_fd_sc_hd__dlygate4sd3_1
Xhold142 uart_rx_raspi_inst.data_reg\[7\] VGND VGND VPWR VPWR net156 sky130_fd_sc_hd__dlygate4sd3_1
Xhold153 dual_watchdog_inst.watchdog_fc.falling_edge_timeout.internal_count\[9\] VGND
+ VGND VPWR VPWR net167 sky130_fd_sc_hd__dlygate4sd3_1
Xhold120 dual_watchdog_inst.watchdog_fc.falling_edge_timeout.assert_time\[15\] VGND
+ VGND VPWR VPWR net134 sky130_fd_sc_hd__dlygate4sd3_1
Xhold186 uart_rx_jetson_inst.bit_cnt\[2\] VGND VGND VPWR VPWR net200 sky130_fd_sc_hd__dlygate4sd3_1
Xhold197 uart_rx_jetson_inst.prescale_reg\[11\] VGND VGND VPWR VPWR net211 sky130_fd_sc_hd__dlygate4sd3_1
Xhold164 dual_watchdog_inst.watchdog_fc.falling_edge_timeout.assert_time\[17\] VGND
+ VGND VPWR VPWR net178 sky130_fd_sc_hd__dlygate4sd3_1
XFILLER_0_13_241 VGND VGND VPWR VPWR sky130_fd_sc_hd__fill_1
Xhold131 uart_tx_raspi_inst.data_reg\[7\] VGND VGND VPWR VPWR net145 sky130_fd_sc_hd__dlygate4sd3_1
XTAP_491 VGND VPWR sky130_fd_sc_hd__tapvpwrvgnd_1
XTAP_480 VGND VPWR sky130_fd_sc_hd__tapvpwrvgnd_1
XFILLER_0_54_141 VPWR VGND VPWR VGND sky130_ef_sc_hd__decap_12
XFILLER_0_42_303 VGND VGND VPWR VPWR sky130_fd_sc_hd__decap_4
XFILLER_0_39_160 VGND VGND VPWR VPWR sky130_fd_sc_hd__fill_2
XFILLER_0_40_76 VGND VGND VPWR VPWR sky130_fd_sc_hd__decap_8
XFILLER_0_24_99 VGND VGND VPWR VPWR sky130_fd_sc_hd__fill_2
XFILLER_0_57_6 VPWR VGND VPWR VGND sky130_ef_sc_hd__decap_12
X_1515_ net58 _0393_ _0395_ VGND VGND VPWR VPWR _0158_ sky130_fd_sc_hd__a21boi_1
X_1377_ _0983_ VGND VGND VPWR VPWR _0123_ sky130_fd_sc_hd__clkbuf_1
X_1446_ _0966_ net31 _0345_ VGND VGND VPWR VPWR _0139_ sky130_fd_sc_hd__a21oi_1
XFILLER_0_4_98 VGND VGND VPWR VPWR sky130_fd_sc_hd__fill_2
XFILLER_0_10_288 VGND VGND VPWR VPWR sky130_fd_sc_hd__decap_4
XFILLER_0_60_133 VGND VGND VPWR VPWR sky130_fd_sc_hd__decap_6
X_1231_ _0874_ VGND VGND VPWR VPWR _0875_ sky130_fd_sc_hd__clkbuf_2
X_1300_ net120 dual_watchdog_inst.watchdog_fc.rising_edge_timeout.internal_count\[24\]
+ _0919_ _0921_ _0764_ VGND VGND VPWR VPWR _0047_ sky130_fd_sc_hd__a311oi_1
X_1162_ _0825_ _0827_ dual_watchdog_inst.watchdog_fc.falling_edge_timeout.internal_count\[6\]
+ VGND VGND VPWR VPWR _0830_ sky130_fd_sc_hd__a21o_1
X_2280_ clknet_leaf_25_clk _0305_ net8 VGND VGND VPWR VPWR dual_watchdog_inst.watchdog_fc.falling_edge_timeout.assert_time\[16\]
+ sky130_fd_sc_hd__dfrtp_1
XFILLER_0_35_98 VGND VGND VPWR VPWR sky130_fd_sc_hd__decap_3
X_1093_ net119 _0743_ _0779_ _0759_ VGND VGND VPWR VPWR _0238_ sky130_fd_sc_hd__a211oi_1
XFILLER_0_42_122 VPWR VGND VPWR VGND sky130_ef_sc_hd__decap_12
XFILLER_0_30_306 VGND VGND VPWR VPWR sky130_fd_sc_hd__fill_2
XFILLER_0_27_141 VGND VGND VPWR VPWR sky130_fd_sc_hd__fill_2
XFILLER_0_15_325 VGND VGND VPWR VPWR sky130_fd_sc_hd__decap_3
X_1995_ _0691_ _0689_ _0694_ _0820_ VGND VGND VPWR VPWR _0312_ sky130_fd_sc_hd__a211oi_1
XFILLER_0_55_3 VGND VGND VPWR VPWR sky130_fd_sc_hd__decap_6
X_1429_ net236 _0329_ VGND VGND VPWR VPWR _0333_ sky130_fd_sc_hd__nand2_1
XFILLER_0_30_339 VGND VGND VPWR VPWR sky130_fd_sc_hd__decap_6
XFILLER_0_18_141 VGND VGND VPWR VPWR sky130_fd_sc_hd__decap_4
XFILLER_0_33_166 VGND VGND VPWR VPWR sky130_fd_sc_hd__fill_2
X_1780_ uart_tx_raspi_inst.prescale_reg\[17\] uart_tx_raspi_inst.prescale_reg\[16\]
+ _0938_ VGND VGND VPWR VPWR _0564_ sky130_fd_sc_hd__or3_1
X_2263_ clknet_leaf_6_clk _0048_ _0110_ VGND VGND VPWR VPWR dual_watchdog_inst.watchdog_fc.rising_edge_timeout.internal_count\[26\]
+ sky130_fd_sc_hd__dfrtp_1
XFILLER_0_46_53 VPWR VGND VPWR VGND sky130_ef_sc_hd__decap_12
X_2194_ clknet_leaf_15_clk _0274_ VGND VGND VPWR VPWR uart_tx_raspi_inst.prescale_reg\[8\]
+ sky130_fd_sc_hd__dfxtp_1
XFILLER_0_1_55 VGND VGND VPWR VPWR sky130_fd_sc_hd__fill_1
X_1214_ dual_watchdog_inst.watchdog_fc.falling_edge_timeout.internal_count\[19\] dual_watchdog_inst.watchdog_fc.falling_edge_timeout.internal_count\[18\]
+ _0853_ _0864_ VGND VGND VPWR VPWR _0865_ sky130_fd_sc_hd__and4_1
X_1145_ _0819_ VGND VGND VPWR VPWR _0002_ sky130_fd_sc_hd__buf_1
XFILLER_0_47_203 VGND VGND VPWR VPWR sky130_fd_sc_hd__decap_4
X_1076_ dual_watchdog_inst.watchdog_fc.rising_edge_timeout.assert_time\[18\] net98
+ _0747_ _0769_ _0759_ VGND VGND VPWR VPWR _0245_ sky130_fd_sc_hd__a311oi_1
XFILLER_0_7_300 VGND VGND VPWR VPWR sky130_fd_sc_hd__fill_1
X_1978_ dual_watchdog_inst.watchdog_fc.falling_edge_timeout.assert_time\[19\] dual_watchdog_inst.watchdog_fc.falling_edge_timeout.assert_time\[18\]
+ _0676_ _0678_ VGND VGND VPWR VPWR _0682_ sky130_fd_sc_hd__and4_1
Xhold46 uart_tx_jetson_inst.prescale_reg\[17\] VGND VGND VPWR VPWR net60 sky130_fd_sc_hd__dlygate4sd3_1
Xhold57 dual_watchdog_inst.watchdog_fc.rising_edge_timeout.internal_count\[5\] VGND
+ VGND VPWR VPWR net71 sky130_fd_sc_hd__dlygate4sd3_1
Xhold13 _0281_ VGND VGND VPWR VPWR net27 sky130_fd_sc_hd__dlygate4sd3_1
Xhold79 uart_tx_raspi_inst.prescale_reg\[17\] VGND VGND VPWR VPWR net93 sky130_fd_sc_hd__dlygate4sd3_1
Xhold35 uart_rx_raspi_inst.prescale_reg\[8\] VGND VGND VPWR VPWR net49 sky130_fd_sc_hd__dlygate4sd3_1
Xhold68 uart_rx_jetson_inst.prescale_reg\[14\] VGND VGND VPWR VPWR net82 sky130_fd_sc_hd__dlygate4sd3_1
Xhold24 _0256_ VGND VGND VPWR VPWR net38 sky130_fd_sc_hd__dlygate4sd3_1
XFILLER_0_38_236 VGND VGND VPWR VPWR sky130_fd_sc_hd__decap_3
XTAP_309 VGND VPWR sky130_fd_sc_hd__tapvpwrvgnd_1
XFILLER_0_21_147 VGND VGND VPWR VPWR sky130_fd_sc_hd__fill_2
X_1901_ _0638_ VGND VGND VPWR VPWR _0096_ sky130_fd_sc_hd__inv_2
XFILLER_0_32_44 VGND VGND VPWR VPWR sky130_fd_sc_hd__fill_2
XFILLER_0_29_269 VGND VGND VPWR VPWR sky130_fd_sc_hd__decap_3
XFILLER_0_29_225 VGND VGND VPWR VPWR sky130_fd_sc_hd__fill_1
X_1832_ _0596_ _0600_ VGND VGND VPWR VPWR _0601_ sky130_fd_sc_hd__and2_1
X_1763_ _0560_ VGND VGND VPWR VPWR _0071_ sky130_fd_sc_hd__inv_2
X_1694_ _0499_ _0523_ _0520_ VGND VGND VPWR VPWR _0209_ sky130_fd_sc_hd__a21oi_1
XFILLER_0_12_158 VGND VGND VPWR VPWR sky130_fd_sc_hd__fill_1
XFILLER_0_57_30 VGND VGND VPWR VPWR sky130_fd_sc_hd__fill_1
X_2246_ clknet_leaf_5_clk _0056_ _0093_ VGND VGND VPWR VPWR dual_watchdog_inst.watchdog_fc.rising_edge_timeout.internal_count\[9\]
+ sky130_fd_sc_hd__dfrtp_1
X_2177_ clknet_leaf_10_clk _0257_ VGND VGND VPWR VPWR uart_tx_jetson_inst.data_reg\[0\]
+ sky130_fd_sc_hd__dfxtp_1
X_1059_ _0758_ VGND VGND VPWR VPWR _0759_ sky130_fd_sc_hd__clkbuf_4
X_1128_ dual_watchdog_inst.watchdog_fc.falling_edge_timeout.internal_count\[21\] dual_watchdog_inst.watchdog_fc.falling_edge_timeout.internal_count\[20\]
+ dual_watchdog_inst.watchdog_fc.falling_edge_timeout.internal_count\[25\] dual_watchdog_inst.watchdog_fc.falling_edge_timeout.internal_count\[24\]
+ VGND VGND VPWR VPWR _0803_ sky130_fd_sc_hd__nand4_1
XFILLER_0_43_250 VGND VGND VPWR VPWR sky130_fd_sc_hd__fill_1
XFILLER_0_7_185 VGND VGND VPWR VPWR sky130_fd_sc_hd__fill_2
XFILLER_0_43_272 VGND VGND VPWR VPWR sky130_fd_sc_hd__decap_8
XPHY_120 VGND VGND VPWR VPWR sky130_fd_sc_hd__decap_3
XFILLER_0_58_309 VPWR VGND VPWR VGND sky130_ef_sc_hd__decap_12
XFILLER_0_1_317 VPWR VGND VPWR VGND sky130_ef_sc_hd__decap_12
XTAP_128 VGND VPWR sky130_fd_sc_hd__tapvpwrvgnd_1
X_2100_ clknet_leaf_22_clk net20 VGND VGND VPWR VPWR rst_cnt\[0\] sky130_fd_sc_hd__dfxtp_1
XTAP_139 VGND VPWR sky130_fd_sc_hd__tapvpwrvgnd_1
XFILLER_0_43_21 VGND VGND VPWR VPWR sky130_fd_sc_hd__fill_1
XPHY_0 VGND VGND VPWR VPWR sky130_fd_sc_hd__decap_3
X_2031_ clknet_leaf_23_clk _0000_ VGND VGND VPWR VPWR uart_rst sky130_fd_sc_hd__dfxtp_2
X_1815_ uart_tx_raspi_inst.prescale_reg\[0\] _0940_ VGND VGND VPWR VPWR _0588_ sky130_fd_sc_hd__and2b_1
XFILLER_0_4_133 VGND VGND VPWR VPWR sky130_fd_sc_hd__decap_6
X_1746_ net12 VGND VGND VPWR VPWR _0558_ sky130_fd_sc_hd__buf_4
XFILLER_0_7_65 VGND VGND VPWR VPWR sky130_fd_sc_hd__decap_4
XFILLER_0_4_188 VGND VGND VPWR VPWR sky130_fd_sc_hd__decap_8
XFILLER_0_0_361 VGND VGND VPWR VPWR sky130_fd_sc_hd__fill_1
X_1677_ uart_rx_jetson_inst.bit_cnt\[2\] _0477_ VGND VGND VPWR VPWR _0510_ sky130_fd_sc_hd__or2_1
X_2229_ clknet_leaf_23_clk _0015_ net13 VGND VGND VPWR VPWR dual_watchdog_inst.watchdog_fc.falling_edge_timeout.internal_count\[20\]
+ sky130_fd_sc_hd__dfrtp_2
XFILLER_0_7_3 VPWR VGND VPWR VGND sky130_ef_sc_hd__decap_12
XFILLER_0_58_139 VGND VGND VPWR VPWR sky130_fd_sc_hd__fill_1
XFILLER_0_13_57 VGND VGND VPWR VPWR sky130_fd_sc_hd__decap_4
X_1531_ _0389_ _0407_ _0399_ VGND VGND VPWR VPWR _0162_ sky130_fd_sc_hd__a21oi_1
X_1462_ _0355_ _0356_ _0345_ VGND VGND VPWR VPWR _0144_ sky130_fd_sc_hd__a21oi_1
XFILLER_0_1_169 VPWR VGND VPWR VGND sky130_ef_sc_hd__decap_12
X_1600_ _0451_ VGND VGND VPWR VPWR _0187_ sky130_fd_sc_hd__clkbuf_1
XFILLER_0_22_231 VPWR VGND VPWR VGND sky130_ef_sc_hd__decap_12
X_1393_ _0994_ VGND VGND VPWR VPWR _0128_ sky130_fd_sc_hd__clkbuf_1
XFILLER_0_38_65 VGND VGND VPWR VPWR sky130_fd_sc_hd__decap_3
X_2014_ uart_rx_jetson_inst.data_reg\[3\] _0501_ VGND VGND VPWR VPWR _0707_ sky130_fd_sc_hd__and2_1
XFILLER_0_60_337 VPWR VGND VPWR VGND sky130_ef_sc_hd__decap_12
Xhold110 uart_tx_jetson_inst.data_reg\[6\] VGND VGND VPWR VPWR net124 sky130_fd_sc_hd__dlygate4sd3_1
XFILLER_0_45_334 VGND VGND VPWR VPWR sky130_fd_sc_hd__fill_2
Xhold154 uart_rx_raspi_inst.data_reg\[5\] VGND VGND VPWR VPWR net168 sky130_fd_sc_hd__dlygate4sd3_1
Xhold165 dual_watchdog_inst.watchdog_fc.rising_edge_timeout.assert_time\[17\] VGND
+ VGND VPWR VPWR net179 sky130_fd_sc_hd__dlygate4sd3_1
Xhold143 uart_tx_raspi_inst.data_reg\[2\] VGND VGND VPWR VPWR net157 sky130_fd_sc_hd__dlygate4sd3_1
Xhold121 _0304_ VGND VGND VPWR VPWR net135 sky130_fd_sc_hd__dlygate4sd3_1
Xhold187 uart_rx_jetson_inst.prescale_reg\[0\] VGND VGND VPWR VPWR net201 sky130_fd_sc_hd__dlygate4sd3_1
Xhold198 _0219_ VGND VGND VPWR VPWR net212 sky130_fd_sc_hd__dlygate4sd3_1
X_1729_ net122 _0546_ VGND VGND VPWR VPWR _0548_ sky130_fd_sc_hd__nand2_1
Xhold176 dual_watchdog_inst.watchdog_fc.falling_edge_timeout.assert_time\[20\] VGND
+ VGND VPWR VPWR net190 sky130_fd_sc_hd__dlygate4sd3_1
Xhold132 uart_tx_raspi_inst.data_reg\[6\] VGND VGND VPWR VPWR net146 sky130_fd_sc_hd__dlygate4sd3_1
XTAP_492 VGND VPWR sky130_fd_sc_hd__tapvpwrvgnd_1
XTAP_481 VGND VPWR sky130_fd_sc_hd__tapvpwrvgnd_1
XTAP_470 VGND VPWR sky130_fd_sc_hd__tapvpwrvgnd_1
XFILLER_0_51_337 VGND VGND VPWR VPWR sky130_fd_sc_hd__fill_1
XFILLER_0_54_197 VGND VGND VPWR VPWR sky130_fd_sc_hd__decap_8
XFILLER_0_54_153 VPWR VGND VPWR VGND sky130_ef_sc_hd__decap_12
XFILLER_0_40_11 VGND VGND VPWR VPWR sky130_fd_sc_hd__fill_2
XFILLER_0_49_20 VGND VGND VPWR VPWR sky130_fd_sc_hd__decap_4
X_1514_ uart_tx_jetson_inst.prescale_reg\[1\] _0393_ _0963_ VGND VGND VPWR VPWR _0395_
+ sky130_fd_sc_hd__o21ba_1
X_1445_ _0344_ VGND VGND VPWR VPWR _0345_ sky130_fd_sc_hd__clkbuf_4
X_1376_ _0964_ _0982_ VGND VGND VPWR VPWR _0983_ sky130_fd_sc_hd__and2b_1
XFILLER_0_33_304 VGND VGND VPWR VPWR sky130_fd_sc_hd__fill_2
XFILLER_0_33_337 VGND VGND VPWR VPWR sky130_fd_sc_hd__decap_4
XFILLER_0_36_164 VGND VGND VPWR VPWR sky130_fd_sc_hd__fill_1
XFILLER_0_51_189 VGND VGND VPWR VPWR sky130_fd_sc_hd__decap_3
X_1230_ dual_watchdog_inst.watchdog_fc.rising_edge_timeout.internal_count\[1\] dual_watchdog_inst.watchdog_fc.rising_edge_timeout.internal_count\[0\]
+ dual_watchdog_inst.watchdog_fc.rising_edge_timeout.internal_count\[3\] dual_watchdog_inst.watchdog_fc.rising_edge_timeout.internal_count\[2\]
+ VGND VGND VPWR VPWR _0874_ sky130_fd_sc_hd__and4_1
X_1092_ dual_watchdog_inst.watchdog_fc.rising_edge_timeout.assert_time\[11\] _0743_
+ VGND VGND VPWR VPWR _0779_ sky130_fd_sc_hd__nor2_1
X_1161_ _0808_ VGND VGND VPWR VPWR _0829_ sky130_fd_sc_hd__buf_2
XFILLER_0_19_78 VGND VGND VPWR VPWR sky130_fd_sc_hd__decap_6
XFILLER_0_59_223 VGND VGND VPWR VPWR sky130_fd_sc_hd__fill_1
XFILLER_0_51_43 VGND VGND VPWR VPWR sky130_fd_sc_hd__decap_4
XFILLER_0_51_32 VGND VGND VPWR VPWR sky130_fd_sc_hd__decap_6
X_1994_ _0693_ VGND VGND VPWR VPWR _0694_ sky130_fd_sc_hd__clkbuf_2
XFILLER_0_51_98 VGND VGND VPWR VPWR sky130_fd_sc_hd__decap_8
XFILLER_0_42_178 VGND VGND VPWR VPWR sky130_fd_sc_hd__decap_6
XFILLER_0_42_134 VGND VGND VPWR VPWR sky130_fd_sc_hd__fill_2
XFILLER_0_30_318 VGND VGND VPWR VPWR sky130_fd_sc_hd__fill_1
XFILLER_0_2_253 VPWR VGND VPWR VGND sky130_ef_sc_hd__decap_12
XFILLER_0_2_242 VGND VGND VPWR VPWR sky130_fd_sc_hd__decap_8
XFILLER_0_15_337 VPWR VGND VPWR VGND sky130_ef_sc_hd__decap_12
XFILLER_0_48_3 VPWR VGND VPWR VGND sky130_ef_sc_hd__decap_12
X_1428_ uart_rx_raspi_inst.prescale_reg\[2\] _0329_ VGND VGND VPWR VPWR _0332_ sky130_fd_sc_hd__or2_1
X_1359_ uart_rx_raspi_inst.prescale_reg\[14\] uart_rx_raspi_inst.prescale_reg\[13\]
+ uart_rx_raspi_inst.prescale_reg\[8\] _0967_ VGND VGND VPWR VPWR _0968_ sky130_fd_sc_hd__or4_4
XFILLER_0_18_197 VGND VGND VPWR VPWR sky130_fd_sc_hd__decap_8
XFILLER_0_21_318 VGND VGND VPWR VPWR sky130_fd_sc_hd__decap_4
X_2262_ clknet_leaf_8_clk net121 _0109_ VGND VGND VPWR VPWR dual_watchdog_inst.watchdog_fc.rising_edge_timeout.internal_count\[25\]
+ sky130_fd_sc_hd__dfrtp_1
X_1213_ dual_watchdog_inst.watchdog_fc.falling_edge_timeout.internal_count\[21\] dual_watchdog_inst.watchdog_fc.falling_edge_timeout.internal_count\[20\]
+ dual_watchdog_inst.watchdog_fc.falling_edge_timeout.internal_count\[23\] dual_watchdog_inst.watchdog_fc.falling_edge_timeout.internal_count\[22\]
+ VGND VGND VPWR VPWR _0864_ sky130_fd_sc_hd__and4_1
XFILLER_0_46_98 VGND VGND VPWR VPWR sky130_fd_sc_hd__fill_2
X_1075_ dual_watchdog_inst.watchdog_fc.rising_edge_timeout.assert_time\[17\] _0747_
+ dual_watchdog_inst.watchdog_fc.rising_edge_timeout.assert_time\[18\] VGND VGND VPWR
+ VPWR _0769_ sky130_fd_sc_hd__a21oi_1
X_2193_ clknet_leaf_19_clk _0273_ VGND VGND VPWR VPWR uart_tx_raspi_inst.prescale_reg\[7\]
+ sky130_fd_sc_hd__dfxtp_1
X_1144_ _0809_ _0818_ VGND VGND VPWR VPWR _0819_ sky130_fd_sc_hd__or2_1
XFILLER_0_55_281 VPWR VGND VPWR VGND sky130_ef_sc_hd__decap_12
XFILLER_0_7_334 VGND VGND VPWR VPWR sky130_fd_sc_hd__fill_2
X_1977_ _0821_ _0680_ _0681_ VGND VGND VPWR VPWR _0307_ sky130_fd_sc_hd__nor3_1
Xhold58 _0878_ VGND VGND VPWR VPWR net72 sky130_fd_sc_hd__dlygate4sd3_1
Xhold25 dual_watchdog_inst.watchdog_fc.rising_edge_timeout.internal_count\[7\] VGND
+ VGND VPWR VPWR net39 sky130_fd_sc_hd__dlygate4sd3_1
Xhold69 uart_tx_jetson_inst.prescale_reg\[11\] VGND VGND VPWR VPWR net83 sky130_fd_sc_hd__dlygate4sd3_1
Xhold47 dual_watchdog_inst.watchdog_fc.rising_edge_timeout.internal_count\[0\] VGND
+ VGND VPWR VPWR net61 sky130_fd_sc_hd__dlygate4sd3_1
Xhold14 uart_rx_jetson_inst.prescale_reg\[6\] VGND VGND VPWR VPWR net28 sky130_fd_sc_hd__dlygate4sd3_1
Xhold36 uart_rx_jetson_inst.prescale_reg\[15\] VGND VGND VPWR VPWR net50 sky130_fd_sc_hd__dlygate4sd3_1
X_1900_ _0638_ VGND VGND VPWR VPWR _0095_ sky130_fd_sc_hd__inv_2
XFILLER_0_37_281 VPWR VGND VPWR VGND sky130_ef_sc_hd__decap_12
X_1831_ net240 _0599_ _0943_ VGND VGND VPWR VPWR _0600_ sky130_fd_sc_hd__a21o_1
XFILLER_0_52_251 VGND VGND VPWR VPWR sky130_fd_sc_hd__fill_1
X_1762_ _0560_ VGND VGND VPWR VPWR _0070_ sky130_fd_sc_hd__inv_2
X_1693_ _0521_ net202 _0504_ VGND VGND VPWR VPWR _0523_ sky130_fd_sc_hd__a21o_1
XFILLER_0_57_86 VPWR VGND VPWR VGND sky130_ef_sc_hd__decap_12
X_2245_ clknet_leaf_5_clk _0055_ _0092_ VGND VGND VPWR VPWR dual_watchdog_inst.watchdog_fc.rising_edge_timeout.internal_count\[8\]
+ sky130_fd_sc_hd__dfrtp_1
X_2176_ clknet_leaf_18_clk net38 VGND VGND VPWR VPWR uart_tx_raspi_inst.s_axis_tready_reg
+ sky130_fd_sc_hd__dfxtp_1
X_1058_ _0737_ VGND VGND VPWR VPWR _0758_ sky130_fd_sc_hd__inv_2
X_1127_ _0797_ _0799_ _0800_ _0801_ VGND VGND VPWR VPWR _0802_ sky130_fd_sc_hd__or4_1
XFILLER_0_9_7 VGND VGND VPWR VPWR sky130_fd_sc_hd__fill_1
XPHY_121 VGND VGND VPWR VPWR sky130_fd_sc_hd__decap_3
XPHY_110 VGND VGND VPWR VPWR sky130_fd_sc_hd__decap_3
XFILLER_0_19_270 VGND VGND VPWR VPWR sky130_fd_sc_hd__decap_3
XFILLER_0_19_281 VGND VGND VPWR VPWR sky130_fd_sc_hd__decap_8
XFILLER_0_1_329 VGND VGND VPWR VPWR sky130_fd_sc_hd__decap_6
XFILLER_0_27_23 VGND VGND VPWR VPWR sky130_fd_sc_hd__fill_2
XTAP_129 VGND VPWR sky130_fd_sc_hd__tapvpwrvgnd_1
X_2030_ _0717_ VGND VGND VPWR VPWR _0323_ sky130_fd_sc_hd__clkbuf_1
XFILLER_0_43_66 VGND VGND VPWR VPWR sky130_fd_sc_hd__decap_6
XPHY_1 VGND VGND VPWR VPWR sky130_fd_sc_hd__decap_3
X_1814_ _0587_ VGND VGND VPWR VPWR _0265_ sky130_fd_sc_hd__clkbuf_1
XFILLER_0_4_112 VGND VGND VPWR VPWR sky130_fd_sc_hd__fill_1
X_1745_ _0557_ VGND VGND VPWR VPWR _0226_ sky130_fd_sc_hd__clkbuf_1
XFILLER_0_40_221 VGND VGND VPWR VPWR sky130_fd_sc_hd__fill_2
X_1676_ _0508_ _0509_ _1002_ VGND VGND VPWR VPWR _0205_ sky130_fd_sc_hd__a21oi_1
X_2159_ clknet_leaf_1_clk _0239_ _0069_ VGND VGND VPWR VPWR dual_watchdog_inst.watchdog_fc.rising_edge_timeout.assert_time\[12\]
+ sky130_fd_sc_hd__dfrtp_1
X_2228_ clknet_leaf_25_clk _0013_ net13 VGND VGND VPWR VPWR dual_watchdog_inst.watchdog_fc.falling_edge_timeout.internal_count\[19\]
+ sky130_fd_sc_hd__dfrtp_1
XFILLER_0_31_243 VGND VGND VPWR VPWR sky130_fd_sc_hd__decap_8
XFILLER_0_54_313 VPWR VGND VPWR VGND sky130_ef_sc_hd__decap_12
Xclkbuf_leaf_24_clk clknet_2_0__leaf_clk VGND VGND VPWR VPWR clknet_leaf_24_clk sky130_fd_sc_hd__clkbuf_16
X_1530_ _0405_ _0406_ _0379_ VGND VGND VPWR VPWR _0407_ sky130_fd_sc_hd__a21o_1
X_1392_ _0986_ _0993_ VGND VGND VPWR VPWR _0994_ sky130_fd_sc_hd__and2b_1
X_1461_ _0352_ net220 VGND VGND VPWR VPWR _0356_ sky130_fd_sc_hd__or2b_1
XFILLER_0_22_243 VGND VGND VPWR VPWR sky130_fd_sc_hd__fill_1
X_2013_ _0706_ VGND VGND VPWR VPWR _0317_ sky130_fd_sc_hd__clkbuf_1
XFILLER_0_57_140 VPWR VGND VPWR VGND sky130_ef_sc_hd__decap_12
Xclkbuf_leaf_15_clk clknet_2_3__leaf_clk VGND VGND VPWR VPWR clknet_leaf_15_clk sky130_fd_sc_hd__clkbuf_16
XFILLER_0_60_349 VPWR VGND VPWR VGND sky130_ef_sc_hd__decap_12
XFILLER_0_60_305 VGND VGND VPWR VPWR sky130_fd_sc_hd__decap_3
Xhold122 uart_tx_jetson_inst.data_reg\[1\] VGND VGND VPWR VPWR net136 sky130_fd_sc_hd__dlygate4sd3_1
Xhold111 dual_watchdog_inst.watchdog_fc.rising_edge_timeout.assert_time\[21\] VGND
+ VGND VPWR VPWR net125 sky130_fd_sc_hd__dlygate4sd3_1
Xhold133 dual_watchdog_inst.watchdog_fc.falling_edge_timeout.assert_time\[9\] VGND
+ VGND VPWR VPWR net147 sky130_fd_sc_hd__dlygate4sd3_1
X_1728_ _0546_ _0547_ _0536_ VGND VGND VPWR VPWR _0219_ sky130_fd_sc_hd__a21oi_1
Xhold100 dual_watchdog_inst.watchdog_fc.falling_edge_timeout.internal_count\[18\]
+ VGND VGND VPWR VPWR net114 sky130_fd_sc_hd__dlygate4sd3_1
Xhold144 dual_watchdog_inst.watchdog_fc.falling_edge_timeout.assert_time\[22\] VGND
+ VGND VPWR VPWR net158 sky130_fd_sc_hd__dlygate4sd3_1
XTAP_493 VGND VPWR sky130_fd_sc_hd__tapvpwrvgnd_1
XTAP_482 VGND VPWR sky130_fd_sc_hd__tapvpwrvgnd_1
XTAP_471 VGND VPWR sky130_fd_sc_hd__tapvpwrvgnd_1
XTAP_460 VGND VPWR sky130_fd_sc_hd__tapvpwrvgnd_1
Xhold166 dual_watchdog_inst.watchdog_fc.rising_edge_timeout.assert_time\[25\] VGND
+ VGND VPWR VPWR net180 sky130_fd_sc_hd__dlygate4sd3_1
Xhold199 dual_watchdog_inst.watchdog_fc.rising_edge_timeout.assert_time\[20\] VGND
+ VGND VPWR VPWR net213 sky130_fd_sc_hd__dlygate4sd3_1
XFILLER_0_0_181 VPWR VGND VPWR VGND sky130_ef_sc_hd__decap_12
Xhold188 _0522_ VGND VGND VPWR VPWR net202 sky130_fd_sc_hd__dlygate4sd3_1
Xhold155 dual_watchdog_inst.watchdog_fc.falling_edge_timeout.internal_count\[17\]
+ VGND VGND VPWR VPWR net169 sky130_fd_sc_hd__dlygate4sd3_1
X_1659_ _1008_ _0494_ VGND VGND VPWR VPWR _0495_ sky130_fd_sc_hd__and2b_1
Xhold177 uart_tx_raspi_inst.bit_cnt\[0\] VGND VGND VPWR VPWR net191 sky130_fd_sc_hd__dlygate4sd3_1
XFILLER_0_39_195 VGND VGND VPWR VPWR sky130_fd_sc_hd__fill_1
XFILLER_0_24_35 VGND VGND VPWR VPWR sky130_fd_sc_hd__fill_1
XFILLER_0_54_176 VGND VGND VPWR VPWR sky130_fd_sc_hd__decap_6
XFILLER_0_54_165 VGND VGND VPWR VPWR sky130_fd_sc_hd__decap_8
XFILLER_0_27_357 VGND VGND VPWR VPWR sky130_fd_sc_hd__decap_4
XFILLER_0_6_218 VPWR VGND VPWR VGND sky130_ef_sc_hd__decap_12
X_1375_ uart_rx_raspi_inst.data_reg\[2\] uart_rx_raspi_inst.m_axis_tdata_reg\[2\]
+ _0977_ VGND VGND VPWR VPWR _0982_ sky130_fd_sc_hd__mux2_1
XFILLER_0_49_65 VGND VGND VPWR VPWR sky130_fd_sc_hd__decap_3
Xclkbuf_leaf_4_clk clknet_2_1__leaf_clk VGND VGND VPWR VPWR clknet_leaf_4_clk sky130_fd_sc_hd__clkbuf_16
X_1513_ _0394_ VGND VGND VPWR VPWR _0157_ sky130_fd_sc_hd__clkbuf_1
X_1444_ uart_rst _1001_ VGND VGND VPWR VPWR _0344_ sky130_fd_sc_hd__or2_1
XFILLER_0_4_12 VGND VGND VPWR VPWR sky130_fd_sc_hd__decap_8
XFILLER_0_60_113 VGND VGND VPWR VPWR sky130_fd_sc_hd__fill_2
XFILLER_0_45_121 VGND VGND VPWR VPWR sky130_fd_sc_hd__fill_2
XFILLER_0_18_302 VGND VGND VPWR VPWR sky130_fd_sc_hd__decap_6
XTAP_290 VGND VPWR sky130_fd_sc_hd__tapvpwrvgnd_1
XFILLER_0_10_15 VGND VGND VPWR VPWR sky130_fd_sc_hd__decap_3
XFILLER_0_10_26 VGND VGND VPWR VPWR sky130_fd_sc_hd__fill_2
XFILLER_0_24_327 VGND VGND VPWR VPWR sky130_fd_sc_hd__fill_1
X_1091_ _0778_ VGND VGND VPWR VPWR _0239_ sky130_fd_sc_hd__clkbuf_1
X_1160_ _0825_ _0827_ net54 VGND VGND VPWR VPWR _0025_ sky130_fd_sc_hd__a21oi_1
XFILLER_0_59_279 VGND VGND VPWR VPWR sky130_fd_sc_hd__fill_1
XFILLER_0_51_11 VGND VGND VPWR VPWR sky130_fd_sc_hd__fill_1
X_1993_ dual_watchdog_inst.watchdog_fc.falling_edge_timeout.assert_time\[21\] dual_watchdog_inst.watchdog_fc.falling_edge_timeout.assert_time\[20\]
+ _0682_ _0692_ VGND VGND VPWR VPWR _0693_ sky130_fd_sc_hd__and4_1
XFILLER_0_2_265 VPWR VGND VPWR VGND sky130_ef_sc_hd__decap_12
X_1427_ _0998_ _0331_ _0328_ VGND VGND VPWR VPWR _0134_ sky130_fd_sc_hd__a21oi_1
X_1358_ uart_rx_raspi_inst.prescale_reg\[12\] uart_rx_raspi_inst.prescale_reg\[11\]
+ uart_rx_raspi_inst.prescale_reg\[10\] uart_rx_raspi_inst.prescale_reg\[9\] VGND
+ VGND VPWR VPWR _0967_ sky130_fd_sc_hd__or4_4
X_1289_ _0727_ _0910_ _0911_ VGND VGND VPWR VPWR _0914_ sky130_fd_sc_hd__or3_1
XFILLER_0_18_121 VPWR VGND VPWR VGND sky130_ef_sc_hd__decap_12
XFILLER_0_56_205 VGND VGND VPWR VPWR sky130_fd_sc_hd__fill_1
X_2261_ clknet_leaf_8_clk _0046_ _0108_ VGND VGND VPWR VPWR dual_watchdog_inst.watchdog_fc.rising_edge_timeout.internal_count\[24\]
+ sky130_fd_sc_hd__dfrtp_2
X_2192_ clknet_leaf_19_clk _0272_ VGND VGND VPWR VPWR uart_tx_raspi_inst.prescale_reg\[6\]
+ sky130_fd_sc_hd__dfxtp_1
X_1212_ net116 VGND VGND VPWR VPWR _0863_ sky130_fd_sc_hd__inv_2
X_1074_ _0768_ VGND VGND VPWR VPWR _0246_ sky130_fd_sc_hd__clkbuf_1
XFILLER_0_1_57 VPWR VGND VPWR VGND sky130_ef_sc_hd__decap_12
X_1143_ _0810_ _0811_ _0812_ _0817_ VGND VGND VPWR VPWR _0818_ sky130_fd_sc_hd__or4_1
XFILLER_0_55_293 VGND VGND VPWR VPWR sky130_fd_sc_hd__fill_2
X_1976_ dual_watchdog_inst.watchdog_fc.falling_edge_timeout.assert_time\[18\] _0676_
+ _0678_ VGND VGND VPWR VPWR _0681_ sky130_fd_sc_hd__and3_1
XFILLER_0_15_113 VPWR VGND VPWR VGND sky130_ef_sc_hd__decap_12
XFILLER_0_60_3 VPWR VGND VPWR VGND sky130_ef_sc_hd__decap_12
Xhold59 uart_tx_jetson_inst.bit_cnt\[2\] VGND VGND VPWR VPWR net73 sky130_fd_sc_hd__dlygate4sd3_1
Xhold15 _0214_ VGND VGND VPWR VPWR net29 sky130_fd_sc_hd__dlygate4sd3_1
Xhold26 uart_rx_jetson_inst.prescale_reg\[7\] VGND VGND VPWR VPWR net40 sky130_fd_sc_hd__dlygate4sd3_1
Xhold37 _0223_ VGND VGND VPWR VPWR net51 sky130_fd_sc_hd__dlygate4sd3_1
Xhold48 dual_watchdog_inst.watchdog_fc.falling_edge_timeout.internal_count\[0\] VGND
+ VGND VPWR VPWR net62 sky130_fd_sc_hd__buf_1
XFILLER_0_53_208 VPWR VGND VPWR VGND sky130_ef_sc_hd__decap_12
XFILLER_0_46_260 VGND VGND VPWR VPWR sky130_fd_sc_hd__decap_8
XFILLER_0_37_293 VGND VGND VPWR VPWR sky130_fd_sc_hd__decap_3
X_1761_ _0560_ VGND VGND VPWR VPWR _0069_ sky130_fd_sc_hd__inv_2
X_1830_ uart_tx_raspi_inst.prescale_reg\[4\] _0933_ VGND VGND VPWR VPWR _0599_ sky130_fd_sc_hd__xnor2_1
X_1692_ uart_rx_jetson_inst.prescale_reg\[1\] net201 VGND VGND VPWR VPWR _0522_ sky130_fd_sc_hd__nand2_1
XFILLER_0_12_149 VGND VGND VPWR VPWR sky130_fd_sc_hd__decap_4
X_2244_ clknet_leaf_4_clk _0054_ _0091_ VGND VGND VPWR VPWR dual_watchdog_inst.watchdog_fc.rising_edge_timeout.internal_count\[7\]
+ sky130_fd_sc_hd__dfrtp_1
X_1126_ dual_watchdog_inst.watchdog_fc.falling_edge_timeout.internal_count\[10\] dual_watchdog_inst.watchdog_fc.falling_edge_timeout.internal_count\[13\]
+ dual_watchdog_inst.watchdog_fc.falling_edge_timeout.internal_count\[11\] VGND VGND
+ VPWR VPWR _0801_ sky130_fd_sc_hd__or3b_1
X_2175_ clknet_leaf_19_clk _0255_ VGND VGND VPWR VPWR net6 sky130_fd_sc_hd__dfxtp_1
X_1057_ _0755_ _0756_ _0757_ net180 _0738_ VGND VGND VPWR VPWR _0252_ sky130_fd_sc_hd__o221a_1
X_1959_ dual_watchdog_inst.watchdog_fc.falling_edge_timeout.assert_time\[13\] dual_watchdog_inst.watchdog_fc.falling_edge_timeout.assert_time\[12\]
+ VGND VGND VPWR VPWR _0669_ sky130_fd_sc_hd__and2_1
XPHY_100 VGND VGND VPWR VPWR sky130_fd_sc_hd__decap_3
XPHY_111 VGND VGND VPWR VPWR sky130_fd_sc_hd__decap_3
Xclkbuf_0_clk clk VGND VGND VPWR VPWR clknet_0_clk sky130_fd_sc_hd__clkbuf_16
XPHY_2 VGND VGND VPWR VPWR sky130_fd_sc_hd__decap_3
X_1813_ _0391_ net115 _0571_ VGND VGND VPWR VPWR _0587_ sky130_fd_sc_hd__mux2_1
XFILLER_0_40_244 VGND VGND VPWR VPWR sky130_fd_sc_hd__fill_1
XFILLER_0_25_241 VGND VGND VPWR VPWR sky130_fd_sc_hd__fill_1
XFILLER_0_4_157 VGND VGND VPWR VPWR sky130_fd_sc_hd__decap_3
X_1744_ _0964_ _0474_ net210 VGND VGND VPWR VPWR _0557_ sky130_fd_sc_hd__and3b_1
X_1675_ net127 _0506_ VGND VGND VPWR VPWR _0509_ sky130_fd_sc_hd__nand2_1
X_2089_ clknet_leaf_13_clk _0169_ VGND VGND VPWR VPWR uart_tx_jetson_inst.prescale_reg\[12\]
+ sky130_fd_sc_hd__dfxtp_1
X_2158_ clknet_leaf_2_clk _0238_ _0068_ VGND VGND VPWR VPWR dual_watchdog_inst.watchdog_fc.rising_edge_timeout.assert_time\[11\]
+ sky130_fd_sc_hd__dfrtp_2
X_1109_ dual_watchdog_inst.watchdog_fc.rising_edge_timeout.assert_time\[4\] _0740_
+ net177 VGND VGND VPWR VPWR _0790_ sky130_fd_sc_hd__a21oi_1
X_2227_ clknet_leaf_23_clk _0012_ net12 VGND VGND VPWR VPWR dual_watchdog_inst.watchdog_fc.falling_edge_timeout.internal_count\[18\]
+ sky130_fd_sc_hd__dfrtp_1
XFILLER_0_23_3 VPWR VGND VPWR VGND sky130_ef_sc_hd__decap_12
XFILLER_0_1_105 VGND VGND VPWR VPWR sky130_fd_sc_hd__decap_6
X_1391_ uart_rx_raspi_inst.data_reg\[7\] uart_rx_raspi_inst.m_axis_tdata_reg\[7\]
+ _0977_ VGND VGND VPWR VPWR _0993_ sky130_fd_sc_hd__mux2_1
XFILLER_0_38_56 VGND VGND VPWR VPWR sky130_fd_sc_hd__fill_1
XFILLER_0_38_23 VGND VGND VPWR VPWR sky130_fd_sc_hd__decap_4
X_1460_ net220 uart_rx_raspi_inst.prescale_reg\[10\] uart_rx_raspi_inst.prescale_reg\[9\]
+ _0349_ VGND VGND VPWR VPWR _0355_ sky130_fd_sc_hd__or4_1
XFILLER_0_54_33 VGND VGND VPWR VPWR sky130_fd_sc_hd__fill_1
X_2012_ _0705_ net194 _0703_ VGND VGND VPWR VPWR _0706_ sky130_fd_sc_hd__mux2_1
XFILLER_0_57_196 VGND VGND VPWR VPWR sky130_fd_sc_hd__decap_3
XFILLER_0_57_152 VPWR VGND VPWR VGND sky130_ef_sc_hd__decap_12
XFILLER_0_45_314 VGND VGND VPWR VPWR sky130_fd_sc_hd__fill_1
Xhold123 dual_watchdog_inst.watchdog_fc.rising_edge_timeout.internal_count\[23\] VGND
+ VGND VPWR VPWR net137 sky130_fd_sc_hd__dlygate4sd3_1
Xhold167 uart_tx_jetson_inst.prescale_reg\[12\] VGND VGND VPWR VPWR net181 sky130_fd_sc_hd__dlygate4sd3_1
Xhold101 uart_tx_jetson_inst.data_reg\[8\] VGND VGND VPWR VPWR net115 sky130_fd_sc_hd__dlygate4sd3_1
Xhold112 _0248_ VGND VGND VPWR VPWR net126 sky130_fd_sc_hd__dlygate4sd3_1
Xhold134 _0298_ VGND VGND VPWR VPWR net148 sky130_fd_sc_hd__dlygate4sd3_1
X_1727_ _0543_ net211 VGND VGND VPWR VPWR _0547_ sky130_fd_sc_hd__or2b_1
X_1658_ uart_rx_jetson_inst.m_axis_tdata_reg\[7\] uart_rx_jetson_inst.data_reg\[7\]
+ _0479_ VGND VGND VPWR VPWR _0494_ sky130_fd_sc_hd__mux2_1
Xhold145 _0312_ VGND VGND VPWR VPWR net159 sky130_fd_sc_hd__dlygate4sd3_1
Xhold156 uart_tx_raspi_inst.data_reg\[4\] VGND VGND VPWR VPWR net170 sky130_fd_sc_hd__dlygate4sd3_1
Xhold178 uart_rx_raspi_inst.data_reg\[1\] VGND VGND VPWR VPWR net192 sky130_fd_sc_hd__dlygate4sd3_1
XTAP_494 VGND VPWR sky130_fd_sc_hd__tapvpwrvgnd_1
XTAP_483 VGND VPWR sky130_fd_sc_hd__tapvpwrvgnd_1
XTAP_472 VGND VPWR sky130_fd_sc_hd__tapvpwrvgnd_1
XTAP_461 VGND VPWR sky130_fd_sc_hd__tapvpwrvgnd_1
XTAP_450 VGND VPWR sky130_fd_sc_hd__tapvpwrvgnd_1
X_1589_ rst_cnt\[1\] net19 net21 VGND VGND VPWR VPWR _0446_ sky130_fd_sc_hd__a21oi_1
XFILLER_0_0_160 VGND VGND VPWR VPWR sky130_fd_sc_hd__decap_8
XFILLER_0_0_193 VGND VGND VPWR VPWR sky130_fd_sc_hd__decap_3
Xhold189 dual_watchdog_inst.watchdog_fc.falling_edge_timeout.internal_count\[15\]
+ VGND VGND VPWR VPWR net203 sky130_fd_sc_hd__dlygate4sd3_1
XFILLER_0_48_141 VPWR VGND VPWR VGND sky130_ef_sc_hd__decap_12
XFILLER_0_39_185 VGND VGND VPWR VPWR sky130_fd_sc_hd__decap_4
XFILLER_0_24_69 VGND VGND VPWR VPWR sky130_fd_sc_hd__fill_1
XFILLER_0_49_11 VGND VGND VPWR VPWR sky130_fd_sc_hd__fill_2
X_1512_ _0986_ _0393_ VGND VGND VPWR VPWR _0394_ sky130_fd_sc_hd__and2b_1
X_1374_ _0981_ VGND VGND VPWR VPWR _0122_ sky130_fd_sc_hd__clkbuf_1
X_1443_ uart_rx_raspi_inst.prescale_reg\[6\] _0340_ VGND VGND VPWR VPWR _0343_ sky130_fd_sc_hd__nand2_1
XFILLER_0_4_46 VGND VGND VPWR VPWR sky130_fd_sc_hd__fill_1
XFILLER_0_45_166 VGND VGND VPWR VPWR sky130_fd_sc_hd__fill_2
XFILLER_0_45_111 VGND VGND VPWR VPWR sky130_fd_sc_hd__fill_1
XFILLER_0_5_241 VGND VGND VPWR VPWR sky130_fd_sc_hd__decap_8
XFILLER_0_60_169 VPWR VGND VPWR VGND sky130_ef_sc_hd__decap_12
XFILLER_0_41_361 VGND VGND VPWR VPWR sky130_fd_sc_hd__fill_1
XTAP_291 VGND VPWR sky130_fd_sc_hd__tapvpwrvgnd_1
XTAP_280 VGND VPWR sky130_fd_sc_hd__tapvpwrvgnd_1
XFILLER_0_36_122 VGND VGND VPWR VPWR sky130_fd_sc_hd__fill_1
XFILLER_0_51_169 VGND VGND VPWR VPWR sky130_fd_sc_hd__decap_3
XFILLER_0_36_177 VGND VGND VPWR VPWR sky130_fd_sc_hd__fill_2
XFILLER_0_32_361 VGND VGND VPWR VPWR sky130_fd_sc_hd__fill_1
XFILLER_0_10_38 VGND VGND VPWR VPWR sky130_fd_sc_hd__fill_2
XFILLER_0_24_306 VGND VGND VPWR VPWR sky130_fd_sc_hd__fill_2
XFILLER_0_59_225 VGND VGND VPWR VPWR sky130_fd_sc_hd__decap_3
XFILLER_0_35_57 VGND VGND VPWR VPWR sky130_fd_sc_hd__decap_6
X_1090_ _0775_ _0766_ _0777_ VGND VGND VPWR VPWR _0778_ sky130_fd_sc_hd__and3b_1
X_1992_ dual_watchdog_inst.watchdog_fc.falling_edge_timeout.assert_time\[23\] dual_watchdog_inst.watchdog_fc.falling_edge_timeout.assert_time\[22\]
+ VGND VGND VPWR VPWR _0692_ sky130_fd_sc_hd__and2_1
XFILLER_0_2_277 VPWR VGND VPWR VGND sky130_ef_sc_hd__decap_12
X_1288_ dual_watchdog_inst.watchdog_fc.rising_edge_timeout.internal_count\[21\] dual_watchdog_inst.watchdog_fc.rising_edge_timeout.internal_count\[20\]
+ _0908_ dual_watchdog_inst.watchdog_fc.rising_edge_timeout.internal_count\[22\] VGND
+ VGND VPWR VPWR _0913_ sky130_fd_sc_hd__a31o_1
X_1426_ _0329_ _0330_ _1001_ VGND VGND VPWR VPWR _0331_ sky130_fd_sc_hd__a21o_1
X_1357_ uart_rx_raspi_inst.prescale_reg\[6\] uart_rx_raspi_inst.prescale_reg\[5\]
+ uart_rx_raspi_inst.prescale_reg\[4\] _0965_ VGND VGND VPWR VPWR _0966_ sky130_fd_sc_hd__or4_4
XFILLER_0_25_90 VGND VGND VPWR VPWR sky130_fd_sc_hd__decap_4
XFILLER_0_56_217 VGND VGND VPWR VPWR sky130_fd_sc_hd__fill_2
XFILLER_0_21_15 VGND VGND VPWR VPWR sky130_fd_sc_hd__fill_2
XFILLER_0_24_136 VGND VGND VPWR VPWR sky130_fd_sc_hd__decap_4
XFILLER_0_12_309 VGND VGND VPWR VPWR sky130_fd_sc_hd__decap_4
X_2260_ clknet_leaf_8_clk _0045_ _0107_ VGND VGND VPWR VPWR dual_watchdog_inst.watchdog_fc.rising_edge_timeout.internal_count\[23\]
+ sky130_fd_sc_hd__dfrtp_1
XFILLER_0_46_89 VGND VGND VPWR VPWR sky130_fd_sc_hd__fill_1
XFILLER_0_46_78 VGND VGND VPWR VPWR sky130_fd_sc_hd__decap_6
XFILLER_0_46_12 VPWR VGND VPWR VGND sky130_ef_sc_hd__decap_12
X_2191_ clknet_leaf_19_clk _0271_ VGND VGND VPWR VPWR uart_tx_raspi_inst.prescale_reg\[5\]
+ sky130_fd_sc_hd__dfxtp_1
X_1142_ _0813_ _0814_ _0815_ _0816_ VGND VGND VPWR VPWR _0817_ sky130_fd_sc_hd__or4_1
X_1211_ _0862_ VGND VGND VPWR VPWR _0017_ sky130_fd_sc_hd__clkbuf_1
X_1073_ _0754_ _0766_ _0767_ VGND VGND VPWR VPWR _0768_ sky130_fd_sc_hd__and3b_1
XFILLER_0_1_69 VPWR VGND VPWR VGND sky130_ef_sc_hd__decap_12
X_1975_ _0676_ _0678_ net218 VGND VGND VPWR VPWR _0680_ sky130_fd_sc_hd__a21oi_1
XFILLER_0_15_125 VGND VGND VPWR VPWR sky130_fd_sc_hd__decap_3
XFILLER_0_15_158 VGND VGND VPWR VPWR sky130_fd_sc_hd__fill_2
XFILLER_0_30_139 VGND VGND VPWR VPWR sky130_fd_sc_hd__fill_1
Xhold27 rst_cnt\[5\] VGND VGND VPWR VPWR net41 sky130_fd_sc_hd__dlygate4sd3_1
Xhold38 rst_cnt\[7\] VGND VGND VPWR VPWR net52 sky130_fd_sc_hd__dlygate4sd3_1
X_1409_ _1008_ VGND VGND VPWR VPWR _1009_ sky130_fd_sc_hd__clkbuf_4
Xhold49 uart_tx_jetson_inst.bit_cnt\[1\] VGND VGND VPWR VPWR net63 sky130_fd_sc_hd__dlygate4sd3_1
XFILLER_0_16_15 VGND VGND VPWR VPWR sky130_fd_sc_hd__decap_6
XFILLER_0_16_59 VGND VGND VPWR VPWR sky130_fd_sc_hd__fill_1
X_1760_ _0560_ VGND VGND VPWR VPWR _0068_ sky130_fd_sc_hd__inv_2
XFILLER_0_4_306 VGND VGND VPWR VPWR sky130_fd_sc_hd__fill_2
X_1691_ uart_rx_jetson_inst.prescale_reg\[1\] uart_rx_jetson_inst.prescale_reg\[0\]
+ VGND VGND VPWR VPWR _0521_ sky130_fd_sc_hd__or2_1
XFILLER_0_57_77 VGND VGND VPWR VPWR sky130_fd_sc_hd__fill_1
X_2243_ clknet_leaf_4_clk _0053_ _0090_ VGND VGND VPWR VPWR dual_watchdog_inst.watchdog_fc.rising_edge_timeout.internal_count\[6\]
+ sky130_fd_sc_hd__dfrtp_1
X_1125_ dual_watchdog_inst.watchdog_fc.falling_edge_timeout.internal_count\[15\] dual_watchdog_inst.watchdog_fc.falling_edge_timeout.internal_count\[19\]
+ dual_watchdog_inst.watchdog_fc.falling_edge_timeout.internal_count\[18\] dual_watchdog_inst.watchdog_fc.falling_edge_timeout.internal_count\[14\]
+ VGND VGND VPWR VPWR _0800_ sky130_fd_sc_hd__or4b_1
X_2174_ clknet_leaf_17_clk _0254_ VGND VGND VPWR VPWR uart_rx_jetson_inst.m_axis_tvalid_reg
+ sky130_fd_sc_hd__dfxtp_1
X_1056_ dual_watchdog_inst.watchdog_fc.rising_edge_timeout.assert_time\[24\] _0754_
+ _0749_ VGND VGND VPWR VPWR _0757_ sky130_fd_sc_hd__and3_1
X_1889_ _0561_ VGND VGND VPWR VPWR _0085_ sky130_fd_sc_hd__inv_2
XFILLER_0_43_242 VGND VGND VPWR VPWR sky130_fd_sc_hd__decap_8
X_1958_ dual_watchdog_inst.watchdog_fc.falling_edge_timeout.assert_time\[12\] _0666_
+ net199 VGND VGND VPWR VPWR _0668_ sky130_fd_sc_hd__a21oi_1
XFILLER_0_3_361 VGND VGND VPWR VPWR sky130_fd_sc_hd__fill_1
XFILLER_0_7_177 VGND VGND VPWR VPWR sky130_fd_sc_hd__decap_8
XPHY_112 VGND VGND VPWR VPWR sky130_fd_sc_hd__decap_3
XPHY_101 VGND VGND VPWR VPWR sky130_fd_sc_hd__decap_3
XPHY_3 VGND VGND VPWR VPWR sky130_fd_sc_hd__decap_3
X_1812_ _0586_ VGND VGND VPWR VPWR _0264_ sky130_fd_sc_hd__clkbuf_1
X_1743_ _0474_ net47 _0536_ VGND VGND VPWR VPWR _0225_ sky130_fd_sc_hd__a21oi_1
X_1674_ uart_rx_jetson_inst.rxd_reg _0497_ _0505_ _0477_ _0507_ VGND VGND VPWR VPWR
+ _0508_ sky130_fd_sc_hd__a221o_1
X_2226_ clknet_leaf_25_clk _0011_ net12 VGND VGND VPWR VPWR dual_watchdog_inst.watchdog_fc.falling_edge_timeout.internal_count\[17\]
+ sky130_fd_sc_hd__dfrtp_1
X_2088_ clknet_leaf_14_clk _0168_ VGND VGND VPWR VPWR uart_tx_jetson_inst.prescale_reg\[11\]
+ sky130_fd_sc_hd__dfxtp_1
X_2157_ clknet_leaf_0_clk _0237_ _0067_ VGND VGND VPWR VPWR dual_watchdog_inst.watchdog_fc.rising_edge_timeout.assert_time\[10\]
+ sky130_fd_sc_hd__dfrtp_1
X_1039_ dual_watchdog_inst.watchdog_fc.rising_edge_timeout.assert_time\[5\] dual_watchdog_inst.watchdog_fc.rising_edge_timeout.assert_time\[4\]
+ VGND VGND VPWR VPWR _0741_ sky130_fd_sc_hd__and2_1
X_1108_ _0789_ VGND VGND VPWR VPWR _0233_ sky130_fd_sc_hd__clkbuf_1
XFILLER_0_16_3 VPWR VGND VPWR VGND sky130_ef_sc_hd__decap_12
XFILLER_0_31_223 VGND VGND VPWR VPWR sky130_fd_sc_hd__fill_1
X_1390_ _0992_ VGND VGND VPWR VPWR _0127_ sky130_fd_sc_hd__clkbuf_1
X_2011_ uart_rx_jetson_inst.data_reg\[2\] _0501_ VGND VGND VPWR VPWR _0705_ sky130_fd_sc_hd__and2_1
XFILLER_0_57_186 VGND VGND VPWR VPWR sky130_fd_sc_hd__fill_1
XFILLER_0_57_164 VGND VGND VPWR VPWR sky130_fd_sc_hd__decap_4
XFILLER_0_45_337 VPWR VGND VPWR VGND sky130_ef_sc_hd__decap_12
Xhold135 dual_watchdog_inst.watchdog_fc.rising_edge_timeout.internal_count\[16\] VGND
+ VGND VPWR VPWR net149 sky130_fd_sc_hd__dlygate4sd3_1
Xhold157 dual_watchdog_inst.watchdog_fc.rising_edge_timeout.assert_time\[14\] VGND
+ VGND VPWR VPWR net171 sky130_fd_sc_hd__dlygate4sd3_1
Xhold146 dual_watchdog_inst.watchdog_fc.falling_edge_timeout.assert_time\[10\] VGND
+ VGND VPWR VPWR net160 sky130_fd_sc_hd__dlygate4sd3_1
Xhold168 dual_watchdog_inst.watchdog_fc.falling_edge_timeout.assert_time\[12\] VGND
+ VGND VPWR VPWR net182 sky130_fd_sc_hd__dlygate4sd3_1
Xhold124 dual_watchdog_inst.watchdog_fc.falling_edge_timeout.internal_count\[8\] VGND
+ VGND VPWR VPWR net138 sky130_fd_sc_hd__dlygate4sd3_1
X_1588_ _0445_ VGND VGND VPWR VPWR _0181_ sky130_fd_sc_hd__clkbuf_1
X_1726_ net211 uart_rx_jetson_inst.prescale_reg\[10\] uart_rx_jetson_inst.prescale_reg\[9\]
+ _0540_ VGND VGND VPWR VPWR _0546_ sky130_fd_sc_hd__or4_1
XFILLER_0_13_223 VGND VGND VPWR VPWR sky130_fd_sc_hd__fill_1
XFILLER_0_13_267 VGND VGND VPWR VPWR sky130_fd_sc_hd__decap_6
Xhold113 uart_rx_jetson_inst.bit_cnt\[1\] VGND VGND VPWR VPWR net127 sky130_fd_sc_hd__dlygate4sd3_1
Xhold102 dual_watchdog_inst.watchdog_fc.falling_edge_timeout.internal_count\[23\]
+ VGND VGND VPWR VPWR net116 sky130_fd_sc_hd__dlygate4sd3_1
X_1657_ _0493_ VGND VGND VPWR VPWR _0202_ sky130_fd_sc_hd__clkbuf_1
Xhold179 uart_tx_raspi_inst.data_reg\[5\] VGND VGND VPWR VPWR net193 sky130_fd_sc_hd__dlygate4sd3_1
XTAP_495 VGND VPWR sky130_fd_sc_hd__tapvpwrvgnd_1
XTAP_484 VGND VPWR sky130_fd_sc_hd__tapvpwrvgnd_1
XTAP_473 VGND VPWR sky130_fd_sc_hd__tapvpwrvgnd_1
XTAP_462 VGND VPWR sky130_fd_sc_hd__tapvpwrvgnd_1
XTAP_451 VGND VPWR sky130_fd_sc_hd__tapvpwrvgnd_1
XTAP_440 VGND VPWR sky130_fd_sc_hd__tapvpwrvgnd_1
X_2209_ clknet_leaf_25_clk _0003_ net12 VGND VGND VPWR VPWR dual_watchdog_inst.watchdog_fc.falling_edge_timeout.internal_count\[0\]
+ sky130_fd_sc_hd__dfrtp_1
XFILLER_0_48_153 VPWR VGND VPWR VGND sky130_ef_sc_hd__decap_12
Xclkbuf_2_0__f_clk clknet_0_clk VGND VGND VPWR VPWR clknet_2_0__leaf_clk sky130_fd_sc_hd__clkbuf_16
XFILLER_0_24_15 VPWR VGND VPWR VGND sky130_ef_sc_hd__decap_12
XFILLER_0_54_134 VGND VGND VPWR VPWR sky130_fd_sc_hd__decap_6
XFILLER_0_42_307 VGND VGND VPWR VPWR sky130_fd_sc_hd__fill_1
XFILLER_0_40_69 VGND VGND VPWR VPWR sky130_fd_sc_hd__fill_1
X_1511_ _0389_ _0390_ _0392_ VGND VGND VPWR VPWR _0393_ sky130_fd_sc_hd__a21oi_1
X_1442_ _0999_ _0342_ _0328_ VGND VGND VPWR VPWR _0138_ sky130_fd_sc_hd__a21oi_1
XFILLER_0_10_248 VGND VGND VPWR VPWR sky130_fd_sc_hd__decap_4
X_1373_ _0964_ _0980_ VGND VGND VPWR VPWR _0981_ sky130_fd_sc_hd__and2b_1
XFILLER_0_45_156 VGND VGND VPWR VPWR sky130_fd_sc_hd__fill_2
XFILLER_0_30_80 VGND VGND VPWR VPWR sky130_fd_sc_hd__decap_4
X_1709_ net28 _0531_ VGND VGND VPWR VPWR _0534_ sky130_fd_sc_hd__nand2_1
XTAP_292 VGND VPWR sky130_fd_sc_hd__tapvpwrvgnd_1
XTAP_281 VGND VPWR sky130_fd_sc_hd__tapvpwrvgnd_1
XTAP_270 VGND VPWR sky130_fd_sc_hd__tapvpwrvgnd_1
XFILLER_0_51_148 VPWR VGND VPWR VGND sky130_ef_sc_hd__decap_12
XFILLER_0_19_15 VGND VGND VPWR VPWR sky130_fd_sc_hd__fill_1
XFILLER_0_19_26 VGND VGND VPWR VPWR sky130_fd_sc_hd__fill_1
XFILLER_0_15_307 VGND VGND VPWR VPWR sky130_fd_sc_hd__fill_2
X_1991_ dual_watchdog_inst.watchdog_fc.falling_edge_timeout.assert_time\[23\] VGND
+ VGND VPWR VPWR _0691_ sky130_fd_sc_hd__inv_2
X_1425_ uart_rx_raspi_inst.prescale_reg\[1\] uart_rx_raspi_inst.prescale_reg\[0\]
+ VGND VGND VPWR VPWR _0330_ sky130_fd_sc_hd__nand2_1
XFILLER_0_2_289 VPWR VGND VPWR VGND sky130_ef_sc_hd__decap_12
X_1287_ _0910_ _0911_ _0912_ _0738_ VGND VGND VPWR VPWR _0043_ sky130_fd_sc_hd__o211a_1
X_1356_ uart_rx_raspi_inst.prescale_reg\[3\] uart_rx_raspi_inst.prescale_reg\[2\]
+ uart_rx_raspi_inst.prescale_reg\[1\] uart_rx_raspi_inst.prescale_reg\[0\] VGND VGND
+ VPWR VPWR _0965_ sky130_fd_sc_hd__or4_4
XFILLER_0_18_145 VGND VGND VPWR VPWR sky130_fd_sc_hd__fill_1
XFILLER_0_21_38 VPWR VGND VPWR VGND sky130_ef_sc_hd__decap_12
XFILLER_0_46_24 VGND VGND VPWR VPWR sky130_fd_sc_hd__decap_4
X_1072_ dual_watchdog_inst.watchdog_fc.rising_edge_timeout.assert_time\[18\] dual_watchdog_inst.watchdog_fc.rising_edge_timeout.assert_time\[17\]
+ _0747_ dual_watchdog_inst.watchdog_fc.rising_edge_timeout.assert_time\[19\] VGND
+ VGND VPWR VPWR _0767_ sky130_fd_sc_hd__a31o_1
X_2190_ clknet_leaf_18_clk _0270_ VGND VGND VPWR VPWR uart_tx_raspi_inst.prescale_reg\[4\]
+ sky130_fd_sc_hd__dfxtp_1
X_1141_ dual_watchdog_inst.watchdog_fc.falling_edge_timeout.assert_time\[9\] dual_watchdog_inst.watchdog_fc.falling_edge_timeout.assert_time\[8\]
+ dual_watchdog_inst.watchdog_fc.falling_edge_timeout.assert_time\[11\] dual_watchdog_inst.watchdog_fc.falling_edge_timeout.assert_time\[10\]
+ VGND VGND VPWR VPWR _0816_ sky130_fd_sc_hd__or4_1
XFILLER_0_1_15 VPWR VGND VPWR VGND sky130_ef_sc_hd__decap_12
X_1210_ _0829_ _0860_ _0861_ VGND VGND VPWR VPWR _0862_ sky130_fd_sc_hd__and3_1
XFILLER_0_47_207 VGND VGND VPWR VPWR sky130_fd_sc_hd__fill_1
X_1974_ _0676_ _0678_ _0679_ _0820_ VGND VGND VPWR VPWR _0306_ sky130_fd_sc_hd__a211oi_1
XFILLER_0_11_310 VGND VGND VPWR VPWR sky130_fd_sc_hd__fill_1
XFILLER_0_23_181 VGND VGND VPWR VPWR sky130_fd_sc_hd__decap_6
XFILLER_0_46_3 VGND VGND VPWR VPWR sky130_fd_sc_hd__decap_6
X_1408_ _0963_ VGND VGND VPWR VPWR _1008_ sky130_fd_sc_hd__clkbuf_4
Xhold17 _0343_ VGND VGND VPWR VPWR net31 sky130_fd_sc_hd__dlygate4sd3_1
Xhold28 _0449_ VGND VGND VPWR VPWR net42 sky130_fd_sc_hd__dlygate4sd3_1
Xhold39 dual_watchdog_inst.watchdog_fc.falling_edge_timeout.internal_count\[5\] VGND
+ VGND VPWR VPWR net53 sky130_fd_sc_hd__dlygate4sd3_1
XFILLER_0_38_218 VGND VGND VPWR VPWR sky130_fd_sc_hd__fill_2
X_1339_ uart_rx_jetson_inst.m_axis_tdata_reg\[4\] uart_tx_raspi_inst.data_reg\[5\]
+ _0930_ VGND VGND VPWR VPWR _0953_ sky130_fd_sc_hd__mux2_1
XFILLER_0_14_170 VPWR VGND VPWR VGND sky130_ef_sc_hd__decap_12
XFILLER_0_16_38 VGND VGND VPWR VPWR sky130_fd_sc_hd__fill_1
XFILLER_0_32_15 VGND VGND VPWR VPWR sky130_fd_sc_hd__decap_4
X_1690_ _0502_ _0517_ _0520_ VGND VGND VPWR VPWR _0208_ sky130_fd_sc_hd__a21oi_1
X_2242_ clknet_leaf_4_clk _0052_ _0089_ VGND VGND VPWR VPWR dual_watchdog_inst.watchdog_fc.rising_edge_timeout.internal_count\[5\]
+ sky130_fd_sc_hd__dfrtp_1
X_1055_ dual_watchdog_inst.watchdog_fc.rising_edge_timeout.assert_time\[25\] dual_watchdog_inst.watchdog_fc.rising_edge_timeout.assert_time\[24\]
+ VGND VGND VPWR VPWR _0756_ sky130_fd_sc_hd__nand2_1
X_2173_ clknet_leaf_3_clk _0253_ _0083_ VGND VGND VPWR VPWR dual_watchdog_inst.watchdog_fc.rising_edge_timeout.assert_time\[26\]
+ sky130_fd_sc_hd__dfrtp_1
X_1124_ dual_watchdog_inst.watchdog_fc.falling_edge_timeout.internal_count\[23\] _0798_
+ dual_watchdog_inst.watchdog_fc.falling_edge_timeout.internal_count\[26\] VGND VGND
+ VPWR VPWR _0799_ sky130_fd_sc_hd__or3b_1
X_1957_ net182 _0666_ _0667_ VGND VGND VPWR VPWR _0301_ sky130_fd_sc_hd__o21a_1
XFILLER_0_7_167 VGND VGND VPWR VPWR sky130_fd_sc_hd__fill_1
XFILLER_0_22_92 VGND VGND VPWR VPWR sky130_fd_sc_hd__decap_8
X_1888_ _0561_ VGND VGND VPWR VPWR _0084_ sky130_fd_sc_hd__inv_2
XPHY_113 VGND VGND VPWR VPWR sky130_fd_sc_hd__decap_3
XPHY_102 VGND VGND VPWR VPWR sky130_fd_sc_hd__decap_3
XFILLER_0_27_15 VGND VGND VPWR VPWR sky130_fd_sc_hd__decap_8
Xclkbuf_leaf_27_clk clknet_2_0__leaf_clk VGND VGND VPWR VPWR clknet_leaf_27_clk sky130_fd_sc_hd__clkbuf_16
XFILLER_0_57_335 VGND VGND VPWR VPWR sky130_fd_sc_hd__fill_1
X_1811_ _0585_ net140 _0571_ VGND VGND VPWR VPWR _0586_ sky130_fd_sc_hd__mux2_1
XPHY_4 VGND VGND VPWR VPWR sky130_fd_sc_hd__decap_3
XFILLER_0_40_213 VGND VGND VPWR VPWR sky130_fd_sc_hd__decap_8
XFILLER_0_7_36 VGND VGND VPWR VPWR sky130_fd_sc_hd__decap_4
XFILLER_0_0_321 VGND VGND VPWR VPWR sky130_fd_sc_hd__decap_4
X_1673_ uart_rx_jetson_inst.rxd_reg _0496_ _0476_ _0506_ VGND VGND VPWR VPWR _0507_
+ sky130_fd_sc_hd__a31o_1
X_1742_ uart_rx_jetson_inst.prescale_reg\[16\] _0473_ net46 VGND VGND VPWR VPWR _0556_
+ sky130_fd_sc_hd__o21ai_1
X_2225_ clknet_leaf_23_clk _0010_ net14 VGND VGND VPWR VPWR dual_watchdog_inst.watchdog_fc.falling_edge_timeout.internal_count\[16\]
+ sky130_fd_sc_hd__dfrtp_1
X_2087_ clknet_leaf_14_clk _0167_ VGND VGND VPWR VPWR uart_tx_jetson_inst.prescale_reg\[10\]
+ sky130_fd_sc_hd__dfxtp_1
X_1038_ _0739_ VGND VGND VPWR VPWR _0740_ sky130_fd_sc_hd__clkbuf_2
X_1107_ _0785_ _0766_ _0788_ VGND VGND VPWR VPWR _0789_ sky130_fd_sc_hd__and3b_1
X_2156_ clknet_leaf_0_clk net173 _0066_ VGND VGND VPWR VPWR dual_watchdog_inst.watchdog_fc.rising_edge_timeout.assert_time\[9\]
+ sky130_fd_sc_hd__dfrtp_1
Xclkbuf_leaf_18_clk clknet_2_2__leaf_clk VGND VGND VPWR VPWR clknet_leaf_18_clk sky130_fd_sc_hd__clkbuf_16
XFILLER_0_16_287 VGND VGND VPWR VPWR sky130_fd_sc_hd__decap_4
XFILLER_0_31_279 VGND VGND VPWR VPWR sky130_fd_sc_hd__fill_1
XFILLER_0_54_338 VPWR VGND VPWR VGND sky130_ef_sc_hd__decap_12
XFILLER_0_54_305 VGND VGND VPWR VPWR sky130_fd_sc_hd__decap_3
XFILLER_0_38_36 VPWR VGND VPWR VGND sky130_ef_sc_hd__decap_12
X_2010_ _0704_ VGND VGND VPWR VPWR _0316_ sky130_fd_sc_hd__clkbuf_1
XFILLER_0_45_349 VPWR VGND VPWR VGND sky130_ef_sc_hd__decap_12
X_1725_ _0502_ _0545_ _0520_ VGND VGND VPWR VPWR _0218_ sky130_fd_sc_hd__a21oi_1
Xhold125 uart_tx_jetson_inst.data_reg\[3\] VGND VGND VPWR VPWR net139 sky130_fd_sc_hd__dlygate4sd3_1
Xclkbuf_leaf_7_clk clknet_2_1__leaf_clk VGND VGND VPWR VPWR clknet_leaf_7_clk sky130_fd_sc_hd__clkbuf_16
XTAP_441 VGND VPWR sky130_fd_sc_hd__tapvpwrvgnd_1
XTAP_430 VGND VPWR sky130_fd_sc_hd__tapvpwrvgnd_1
Xhold103 dual_watchdog_inst.watchdog_fc.rising_edge_timeout.assert_time\[23\] VGND
+ VGND VPWR VPWR net117 sky130_fd_sc_hd__dlygate4sd3_1
Xhold136 uart_rx_raspi_inst.bit_cnt\[0\] VGND VGND VPWR VPWR net150 sky130_fd_sc_hd__dlygate4sd3_1
Xhold147 uart_tx_raspi_inst.prescale_reg\[7\] VGND VGND VPWR VPWR net161 sky130_fd_sc_hd__dlygate4sd3_1
Xhold114 uart_rx_raspi_inst.prescale_reg\[12\] VGND VGND VPWR VPWR net128 sky130_fd_sc_hd__dlygate4sd3_1
Xhold158 dual_watchdog_inst.watchdog_fc.rising_edge_timeout.assert_time\[9\] VGND
+ VGND VPWR VPWR net172 sky130_fd_sc_hd__dlygate4sd3_1
X_1587_ net19 _0180_ net233 VGND VGND VPWR VPWR _0445_ sky130_fd_sc_hd__mux2_1
XFILLER_0_13_279 VGND VGND VPWR VPWR sky130_fd_sc_hd__fill_1
X_1656_ _1008_ _0492_ VGND VGND VPWR VPWR _0493_ sky130_fd_sc_hd__and2b_1
Xhold169 net6 VGND VGND VPWR VPWR net183 sky130_fd_sc_hd__dlygate4sd3_1
XTAP_496 VGND VPWR sky130_fd_sc_hd__tapvpwrvgnd_1
XTAP_485 VGND VPWR sky130_fd_sc_hd__tapvpwrvgnd_1
XTAP_474 VGND VPWR sky130_fd_sc_hd__tapvpwrvgnd_1
XTAP_463 VGND VPWR sky130_fd_sc_hd__tapvpwrvgnd_1
XTAP_452 VGND VPWR sky130_fd_sc_hd__tapvpwrvgnd_1
XFILLER_0_28_91 VGND VGND VPWR VPWR sky130_fd_sc_hd__fill_2
X_2139_ clknet_leaf_20_clk net212 VGND VGND VPWR VPWR uart_rx_jetson_inst.prescale_reg\[11\]
+ sky130_fd_sc_hd__dfxtp_1
X_2208_ clknet_leaf_19_clk _0288_ VGND VGND VPWR VPWR uart_tx_raspi_inst.bit_cnt\[3\]
+ sky130_fd_sc_hd__dfxtp_1
XFILLER_0_48_165 VPWR VGND VPWR VGND sky130_ef_sc_hd__decap_12
XFILLER_0_8_251 VGND VGND VPWR VPWR sky130_fd_sc_hd__fill_1
XFILLER_0_44_360 VGND VGND VPWR VPWR sky130_fd_sc_hd__fill_2
XFILLER_0_39_132 VGND VGND VPWR VPWR sky130_fd_sc_hd__decap_6
XFILLER_0_39_121 VGND VGND VPWR VPWR sky130_fd_sc_hd__decap_3
XFILLER_0_24_27 VGND VGND VPWR VPWR sky130_fd_sc_hd__fill_1
XFILLER_0_40_37 VGND VGND VPWR VPWR sky130_fd_sc_hd__fill_2
XFILLER_0_49_24 VGND VGND VPWR VPWR sky130_fd_sc_hd__fill_1
X_1510_ uart_rx_raspi_inst.m_axis_tvalid_reg _0378_ _0391_ VGND VGND VPWR VPWR _0392_
+ sky130_fd_sc_hd__and3b_1
X_1441_ _0340_ _0341_ _1001_ VGND VGND VPWR VPWR _0342_ sky130_fd_sc_hd__a21o_1
X_1372_ uart_rx_raspi_inst.data_reg\[1\] uart_rx_raspi_inst.m_axis_tdata_reg\[1\]
+ net17 VGND VGND VPWR VPWR _0980_ sky130_fd_sc_hd__mux2_2
XFILLER_0_5_221 VGND VGND VPWR VPWR sky130_fd_sc_hd__decap_3
X_1708_ _0502_ _0533_ _0520_ VGND VGND VPWR VPWR _0213_ sky130_fd_sc_hd__a21oi_1
XFILLER_0_39_90 VGND VGND VPWR VPWR sky130_fd_sc_hd__fill_1
X_1639_ _0481_ VGND VGND VPWR VPWR _0196_ sky130_fd_sc_hd__clkbuf_1
XTAP_293 VGND VPWR sky130_fd_sc_hd__tapvpwrvgnd_1
XTAP_282 VGND VPWR sky130_fd_sc_hd__tapvpwrvgnd_1
XTAP_260 VGND VPWR sky130_fd_sc_hd__tapvpwrvgnd_1
XTAP_271 VGND VPWR sky130_fd_sc_hd__tapvpwrvgnd_1
XFILLER_0_51_127 VGND VGND VPWR VPWR sky130_fd_sc_hd__fill_1
XFILLER_0_10_29 VGND VGND VPWR VPWR sky130_fd_sc_hd__decap_3
XFILLER_0_35_15 VGND VGND VPWR VPWR sky130_fd_sc_hd__decap_4
XFILLER_0_51_47 VGND VGND VPWR VPWR sky130_fd_sc_hd__fill_1
X_1990_ _0690_ VGND VGND VPWR VPWR _0311_ sky130_fd_sc_hd__clkbuf_1
XFILLER_0_2_213 VGND VGND VPWR VPWR sky130_fd_sc_hd__fill_1
X_1424_ uart_rx_raspi_inst.prescale_reg\[1\] uart_rx_raspi_inst.prescale_reg\[0\]
+ VGND VGND VPWR VPWR _0329_ sky130_fd_sc_hd__or2_1
X_1355_ _0963_ VGND VGND VPWR VPWR _0964_ sky130_fd_sc_hd__clkbuf_4
X_1286_ dual_watchdog_inst.watchdog_fc.rising_edge_timeout.internal_count\[20\] _0908_
+ dual_watchdog_inst.watchdog_fc.rising_edge_timeout.internal_count\[21\] VGND VGND
+ VPWR VPWR _0912_ sky130_fd_sc_hd__a21o_1
XFILLER_0_58_271 VPWR VGND VPWR VGND sky130_ef_sc_hd__decap_12
XFILLER_0_33_116 VGND VGND VPWR VPWR sky130_fd_sc_hd__decap_4
XFILLER_0_24_149 VPWR VGND VPWR VGND sky130_ef_sc_hd__decap_12
XFILLER_0_20_322 VGND VGND VPWR VPWR sky130_fd_sc_hd__fill_1
X_1071_ _0731_ _0734_ _0735_ _0736_ VGND VGND VPWR VPWR _0766_ sky130_fd_sc_hd__or4_4
XFILLER_0_1_27 VPWR VGND VPWR VGND sky130_ef_sc_hd__decap_12
X_1140_ dual_watchdog_inst.watchdog_fc.falling_edge_timeout.assert_time\[13\] dual_watchdog_inst.watchdog_fc.falling_edge_timeout.assert_time\[12\]
+ dual_watchdog_inst.watchdog_fc.falling_edge_timeout.assert_time\[15\] dual_watchdog_inst.watchdog_fc.falling_edge_timeout.assert_time\[14\]
+ VGND VGND VPWR VPWR _0815_ sky130_fd_sc_hd__or4_1
X_1973_ dual_watchdog_inst.watchdog_fc.falling_edge_timeout.assert_time\[16\] _0676_
+ net178 VGND VGND VPWR VPWR _0679_ sky130_fd_sc_hd__a21oi_1
XFILLER_0_39_3 VGND VGND VPWR VPWR sky130_fd_sc_hd__decap_8
X_1407_ net104 net18 VGND VGND VPWR VPWR _1007_ sky130_fd_sc_hd__nand2_1
Xhold18 _0139_ VGND VGND VPWR VPWR net32 sky130_fd_sc_hd__dlygate4sd3_1
Xhold29 _0185_ VGND VGND VPWR VPWR net43 sky130_fd_sc_hd__dlygate4sd3_1
X_1338_ _0952_ VGND VGND VPWR VPWR _0115_ sky130_fd_sc_hd__clkbuf_1
X_1269_ _0898_ _0900_ VGND VGND VPWR VPWR _0036_ sky130_fd_sc_hd__nor2_1
XFILLER_0_36_91 VGND VGND VPWR VPWR sky130_fd_sc_hd__decap_8
XFILLER_0_14_182 VGND VGND VPWR VPWR sky130_fd_sc_hd__decap_6
XFILLER_0_37_263 VGND VGND VPWR VPWR sky130_fd_sc_hd__fill_1
XFILLER_0_32_38 VGND VGND VPWR VPWR sky130_fd_sc_hd__fill_2
XFILLER_0_52_277 VGND VGND VPWR VPWR sky130_fd_sc_hd__decap_6
X_2241_ clknet_leaf_4_clk _0051_ _0088_ VGND VGND VPWR VPWR dual_watchdog_inst.watchdog_fc.rising_edge_timeout.internal_count\[4\]
+ sky130_fd_sc_hd__dfrtp_1
X_2172_ clknet_leaf_3_clk _0252_ _0082_ VGND VGND VPWR VPWR dual_watchdog_inst.watchdog_fc.rising_edge_timeout.assert_time\[25\]
+ sky130_fd_sc_hd__dfrtp_1
X_1054_ _0754_ _0749_ VGND VGND VPWR VPWR _0755_ sky130_fd_sc_hd__nand2_1
X_1123_ dual_watchdog_inst.watchdog_fc.falling_edge_timeout.internal_count\[22\] VGND
+ VGND VPWR VPWR _0798_ sky130_fd_sc_hd__inv_2
XFILLER_0_43_222 VGND VGND VPWR VPWR sky130_fd_sc_hd__fill_2
XFILLER_0_7_113 VPWR VGND VPWR VGND sky130_ef_sc_hd__decap_12
X_1956_ dual_watchdog_inst.watchdog_fc.falling_edge_timeout.assert_time\[12\] _0666_
+ _0820_ VGND VGND VPWR VPWR _0667_ sky130_fd_sc_hd__a21oi_1
X_1887_ _0636_ _0637_ _1002_ VGND VGND VPWR VPWR _0288_ sky130_fd_sc_hd__a21oi_1
XFILLER_0_22_82 VGND VGND VPWR VPWR sky130_fd_sc_hd__fill_2
XFILLER_0_11_130 VGND VGND VPWR VPWR sky130_fd_sc_hd__fill_2
XPHY_114 VGND VGND VPWR VPWR sky130_fd_sc_hd__decap_3
XPHY_103 VGND VGND VPWR VPWR sky130_fd_sc_hd__decap_3
XFILLER_0_34_277 VGND VGND VPWR VPWR sky130_fd_sc_hd__decap_4
XFILLER_0_43_26 VGND VGND VPWR VPWR sky130_fd_sc_hd__fill_1
XFILLER_0_43_15 VGND VGND VPWR VPWR sky130_fd_sc_hd__decap_6
XPHY_5 VGND VGND VPWR VPWR sky130_fd_sc_hd__decap_3
X_1810_ uart_rx_raspi_inst.m_axis_tdata_reg\[7\] uart_tx_jetson_inst.data_reg\[8\]
+ _0383_ VGND VGND VPWR VPWR _0585_ sky130_fd_sc_hd__mux2_1
X_1741_ _0554_ _0555_ _0536_ VGND VGND VPWR VPWR _0224_ sky130_fd_sc_hd__a21oi_1
XFILLER_0_7_15 VGND VGND VPWR VPWR sky130_fd_sc_hd__fill_1
X_1672_ uart_rx_jetson_inst.prescale_reg\[18\] _0474_ VGND VGND VPWR VPWR _0506_ sky130_fd_sc_hd__or2_4
X_1106_ _0740_ _0741_ dual_watchdog_inst.watchdog_fc.rising_edge_timeout.assert_time\[6\]
+ VGND VGND VPWR VPWR _0788_ sky130_fd_sc_hd__a21o_1
X_2155_ clknet_leaf_0_clk _0235_ _0065_ VGND VGND VPWR VPWR dual_watchdog_inst.watchdog_fc.rising_edge_timeout.assert_time\[8\]
+ sky130_fd_sc_hd__dfrtp_1
X_2224_ clknet_leaf_22_clk _0009_ net14 VGND VGND VPWR VPWR dual_watchdog_inst.watchdog_fc.falling_edge_timeout.internal_count\[15\]
+ sky130_fd_sc_hd__dfrtp_1
X_2086_ clknet_leaf_13_clk _0166_ VGND VGND VPWR VPWR uart_tx_jetson_inst.prescale_reg\[9\]
+ sky130_fd_sc_hd__dfxtp_1
X_1037_ dual_watchdog_inst.watchdog_fc.rising_edge_timeout.assert_time\[3\] dual_watchdog_inst.watchdog_fc.rising_edge_timeout.assert_time\[2\]
+ dual_watchdog_inst.watchdog_fc.rising_edge_timeout.assert_time\[1\] dual_watchdog_inst.watchdog_fc.rising_edge_timeout.assert_time\[0\]
+ VGND VGND VPWR VPWR _0739_ sky130_fd_sc_hd__and4_1
XFILLER_0_31_225 VGND VGND VPWR VPWR sky130_fd_sc_hd__fill_2
X_1939_ dual_watchdog_inst.watchdog_fc.falling_edge_timeout.assert_time\[7\] dual_watchdog_inst.watchdog_fc.falling_edge_timeout.assert_time\[6\]
+ _0645_ _0651_ VGND VGND VPWR VPWR _0655_ sky130_fd_sc_hd__and4_1
XFILLER_0_22_203 VGND VGND VPWR VPWR sky130_fd_sc_hd__decap_4
XFILLER_0_22_214 VGND VGND VPWR VPWR sky130_fd_sc_hd__fill_1
XFILLER_0_38_48 VGND VGND VPWR VPWR sky130_fd_sc_hd__decap_8
XFILLER_0_60_309 VPWR VGND VPWR VGND sky130_ef_sc_hd__decap_12
XFILLER_0_53_361 VGND VGND VPWR VPWR sky130_fd_sc_hd__fill_1
Xhold126 uart_tx_jetson_inst.data_reg\[7\] VGND VGND VPWR VPWR net140 sky130_fd_sc_hd__dlygate4sd3_1
Xhold115 _0358_ VGND VGND VPWR VPWR net129 sky130_fd_sc_hd__dlygate4sd3_1
Xhold104 dual_watchdog_inst.watchdog_fc.falling_edge_timeout.internal_count\[13\]
+ VGND VGND VPWR VPWR net118 sky130_fd_sc_hd__dlygate4sd3_1
X_1724_ _0543_ _0544_ _0506_ VGND VGND VPWR VPWR _0545_ sky130_fd_sc_hd__o21ai_1
XFILLER_0_13_225 VPWR VGND VPWR VGND sky130_ef_sc_hd__decap_12
XFILLER_0_13_258 VGND VGND VPWR VPWR sky130_fd_sc_hd__fill_2
XTAP_475 VGND VPWR sky130_fd_sc_hd__tapvpwrvgnd_1
XTAP_464 VGND VPWR sky130_fd_sc_hd__tapvpwrvgnd_1
XTAP_453 VGND VPWR sky130_fd_sc_hd__tapvpwrvgnd_1
Xhold137 dual_watchdog_inst.watchdog_fc.rising_edge_timeout.internal_count\[11\] VGND
+ VGND VPWR VPWR net151 sky130_fd_sc_hd__dlygate4sd3_1
XTAP_442 VGND VPWR sky130_fd_sc_hd__tapvpwrvgnd_1
XTAP_431 VGND VPWR sky130_fd_sc_hd__tapvpwrvgnd_1
XTAP_420 VGND VPWR sky130_fd_sc_hd__tapvpwrvgnd_1
Xhold159 _0236_ VGND VGND VPWR VPWR net173 sky130_fd_sc_hd__dlygate4sd3_1
X_1586_ net19 _0000_ VGND VGND VPWR VPWR _0180_ sky130_fd_sc_hd__nand2_1
XFILLER_0_0_141 VPWR VGND VPWR VGND sky130_ef_sc_hd__decap_12
X_1655_ uart_rx_jetson_inst.m_axis_tdata_reg\[6\] uart_rx_jetson_inst.data_reg\[6\]
+ _0479_ VGND VGND VPWR VPWR _0492_ sky130_fd_sc_hd__mux2_1
Xhold148 uart_tx_raspi_inst.data_reg\[8\] VGND VGND VPWR VPWR net162 sky130_fd_sc_hd__dlygate4sd3_1
XTAP_497 VGND VPWR sky130_fd_sc_hd__tapvpwrvgnd_1
XTAP_486 VGND VPWR sky130_fd_sc_hd__tapvpwrvgnd_1
X_2138_ clknet_leaf_21_clk _0218_ VGND VGND VPWR VPWR uart_rx_jetson_inst.prescale_reg\[10\]
+ sky130_fd_sc_hd__dfxtp_1
X_2207_ clknet_leaf_19_clk _0287_ VGND VGND VPWR VPWR uart_tx_raspi_inst.bit_cnt\[2\]
+ sky130_fd_sc_hd__dfxtp_1
XFILLER_0_21_3 VPWR VGND VPWR VGND sky130_ef_sc_hd__decap_12
X_2069_ clknet_leaf_24_clk _0149_ VGND VGND VPWR VPWR uart_rx_raspi_inst.prescale_reg\[16\]
+ sky130_fd_sc_hd__dfxtp_1
XFILLER_0_48_177 VPWR VGND VPWR VGND sky130_ef_sc_hd__decap_12
XFILLER_0_12_280 VPWR VGND VPWR VGND sky130_ef_sc_hd__decap_12
XFILLER_0_39_166 VGND VGND VPWR VPWR sky130_fd_sc_hd__fill_2
XFILLER_0_39_111 VGND VGND VPWR VPWR sky130_fd_sc_hd__fill_1
XFILLER_0_24_39 VPWR VGND VPWR VGND sky130_ef_sc_hd__decap_12
XFILLER_0_42_309 VPWR VGND VPWR VGND sky130_ef_sc_hd__decap_12
XFILLER_0_40_16 VPWR VGND VPWR VGND sky130_ef_sc_hd__decap_12
X_1371_ _0979_ VGND VGND VPWR VPWR _0121_ sky130_fd_sc_hd__clkbuf_1
X_1440_ uart_rx_raspi_inst.prescale_reg\[4\] _0965_ uart_rx_raspi_inst.prescale_reg\[5\]
+ VGND VGND VPWR VPWR _0341_ sky130_fd_sc_hd__o21ai_1
XFILLER_0_4_27 VGND VGND VPWR VPWR sky130_fd_sc_hd__fill_1
XFILLER_0_45_169 VGND VGND VPWR VPWR sky130_fd_sc_hd__decap_3
XFILLER_0_45_136 VGND VGND VPWR VPWR sky130_fd_sc_hd__decap_4
XFILLER_0_45_103 VGND VGND VPWR VPWR sky130_fd_sc_hd__decap_8
XFILLER_0_60_139 VGND VGND VPWR VPWR sky130_fd_sc_hd__fill_1
X_1638_ _0986_ _0480_ VGND VGND VPWR VPWR _0481_ sky130_fd_sc_hd__and2b_1
X_1707_ _0531_ _0532_ _0504_ VGND VGND VPWR VPWR _0533_ sky130_fd_sc_hd__a21o_1
X_1569_ net60 _0431_ VGND VGND VPWR VPWR _0434_ sky130_fd_sc_hd__nand2_1
XTAP_294 VGND VPWR sky130_fd_sc_hd__tapvpwrvgnd_1
XTAP_283 VGND VPWR sky130_fd_sc_hd__tapvpwrvgnd_1
XTAP_250 VGND VPWR sky130_fd_sc_hd__tapvpwrvgnd_1
XTAP_261 VGND VPWR sky130_fd_sc_hd__tapvpwrvgnd_1
XTAP_272 VGND VPWR sky130_fd_sc_hd__tapvpwrvgnd_1
Xfanout10 net1 VGND VGND VPWR VPWR net10 sky130_fd_sc_hd__clkbuf_2
XFILLER_0_51_106 VGND VGND VPWR VPWR sky130_fd_sc_hd__decap_3
XFILLER_0_36_169 VGND VGND VPWR VPWR sky130_fd_sc_hd__decap_8
XFILLER_0_17_361 VGND VGND VPWR VPWR sky130_fd_sc_hd__fill_1
XFILLER_0_51_15 VGND VGND VPWR VPWR sky130_fd_sc_hd__decap_8
XFILLER_0_50_194 VGND VGND VPWR VPWR sky130_fd_sc_hd__fill_2
XFILLER_0_23_320 VGND VGND VPWR VPWR sky130_fd_sc_hd__fill_2
XFILLER_0_55_9 VGND VGND VPWR VPWR sky130_fd_sc_hd__fill_1
X_1285_ dual_watchdog_inst.watchdog_fc.rising_edge_timeout.internal_count\[19\] _0906_
+ VGND VGND VPWR VPWR _0911_ sky130_fd_sc_hd__nand2_1
X_1423_ _0999_ _0326_ _0328_ VGND VGND VPWR VPWR _0133_ sky130_fd_sc_hd__a21oi_1
X_1354_ uart_rst VGND VGND VPWR VPWR _0963_ sky130_fd_sc_hd__clkbuf_4
XFILLER_0_58_250 VGND VGND VPWR VPWR sky130_fd_sc_hd__fill_2
XFILLER_0_25_60 VPWR VGND VPWR VGND sky130_ef_sc_hd__decap_12
XFILLER_0_58_283 VPWR VGND VPWR VGND sky130_ef_sc_hd__decap_12
XFILLER_0_33_106 VGND VGND VPWR VPWR sky130_fd_sc_hd__decap_6
XFILLER_0_18_136 VGND VGND VPWR VPWR sky130_fd_sc_hd__decap_4
XFILLER_0_18_169 VPWR VGND VPWR VGND sky130_ef_sc_hd__decap_12
X_1070_ net213 _0754_ _0765_ VGND VGND VPWR VPWR _0247_ sky130_fd_sc_hd__o21a_1
XFILLER_0_1_39 VPWR VGND VPWR VGND sky130_ef_sc_hd__decap_12
X_1972_ dual_watchdog_inst.watchdog_fc.falling_edge_timeout.assert_time\[17\] dual_watchdog_inst.watchdog_fc.falling_edge_timeout.assert_time\[16\]
+ VGND VGND VPWR VPWR _0678_ sky130_fd_sc_hd__and2_1
X_1268_ _0899_ VGND VGND VPWR VPWR _0900_ sky130_fd_sc_hd__clkbuf_2
Xhold19 uart_tx_jetson_inst.prescale_reg\[13\] VGND VGND VPWR VPWR net33 sky130_fd_sc_hd__dlygate4sd3_1
X_1406_ uart_rx_raspi_inst.rxd_reg _0996_ _1005_ net18 VGND VGND VPWR VPWR _1006_
+ sky130_fd_sc_hd__a211o_1
X_1337_ _0951_ net174 _0945_ VGND VGND VPWR VPWR _0952_ sky130_fd_sc_hd__mux2_1
XFILLER_0_46_231 VPWR VGND VPWR VGND sky130_ef_sc_hd__decap_12
X_1199_ net114 _0853_ net219 VGND VGND VPWR VPWR _0854_ sky130_fd_sc_hd__a21oi_1
XFILLER_0_46_297 VGND VGND VPWR VPWR sky130_fd_sc_hd__decap_3
XFILLER_0_52_212 VPWR VGND VPWR VGND sky130_ef_sc_hd__decap_12
XFILLER_0_37_253 VGND VGND VPWR VPWR sky130_fd_sc_hd__fill_1
XFILLER_0_4_309 VPWR VGND VPWR VGND sky130_ef_sc_hd__decap_12
XFILLER_0_52_245 VGND VGND VPWR VPWR sky130_fd_sc_hd__decap_6
X_2240_ clknet_leaf_4_clk _0050_ _0087_ VGND VGND VPWR VPWR dual_watchdog_inst.watchdog_fc.rising_edge_timeout.internal_count\[3\]
+ sky130_fd_sc_hd__dfrtp_1
X_2171_ clknet_leaf_3_clk _0251_ _0081_ VGND VGND VPWR VPWR dual_watchdog_inst.watchdog_fc.rising_edge_timeout.assert_time\[24\]
+ sky130_fd_sc_hd__dfrtp_1
X_1122_ dual_watchdog_inst.watchdog_fc.falling_edge_timeout.internal_count\[12\] VGND
+ VGND VPWR VPWR _0797_ sky130_fd_sc_hd__inv_2
X_1053_ _0748_ VGND VGND VPWR VPWR _0754_ sky130_fd_sc_hd__buf_2
XFILLER_0_28_286 VPWR VGND VPWR VGND sky130_ef_sc_hd__decap_12
XFILLER_0_7_147 VGND VGND VPWR VPWR sky130_fd_sc_hd__decap_4
XFILLER_0_7_125 VPWR VGND VPWR VGND sky130_ef_sc_hd__decap_12
X_1955_ _0664_ _0663_ _0666_ _0821_ VGND VGND VPWR VPWR _0300_ sky130_fd_sc_hd__a211oi_1
X_1886_ uart_tx_raspi_inst.bit_cnt\[2\] _0631_ net106 VGND VGND VPWR VPWR _0637_ sky130_fd_sc_hd__o21ai_1
XFILLER_0_51_3 VGND VGND VPWR VPWR sky130_fd_sc_hd__decap_8
XFILLER_0_11_120 VGND VGND VPWR VPWR sky130_fd_sc_hd__decap_4
XPHY_115 VGND VGND VPWR VPWR sky130_fd_sc_hd__decap_3
XPHY_104 VGND VGND VPWR VPWR sky130_fd_sc_hd__decap_3
XFILLER_0_34_223 VGND VGND VPWR VPWR sky130_fd_sc_hd__fill_1
XFILLER_0_19_231 VGND VGND VPWR VPWR sky130_fd_sc_hd__decap_4
XFILLER_0_19_242 VGND VGND VPWR VPWR sky130_fd_sc_hd__fill_1
XFILLER_0_6_180 VPWR VGND VPWR VGND sky130_ef_sc_hd__decap_12
XFILLER_0_57_337 VPWR VGND VPWR VGND sky130_ef_sc_hd__decap_12
XPHY_6 VGND VGND VPWR VPWR sky130_fd_sc_hd__decap_3
XFILLER_0_25_278 VGND VGND VPWR VPWR sky130_fd_sc_hd__fill_2
XFILLER_0_4_139 VGND VGND VPWR VPWR sky130_fd_sc_hd__fill_1
X_1671_ uart_rx_jetson_inst.bit_cnt\[1\] uart_rx_jetson_inst.bit_cnt\[0\] VGND VGND
+ VPWR VPWR _0505_ sky130_fd_sc_hd__nand2_1
X_1740_ net69 _0473_ VGND VGND VPWR VPWR _0555_ sky130_fd_sc_hd__nand2_1
X_2085_ clknet_leaf_13_clk _0165_ VGND VGND VPWR VPWR uart_tx_jetson_inst.prescale_reg\[8\]
+ sky130_fd_sc_hd__dfxtp_1
X_1105_ _0787_ VGND VGND VPWR VPWR _0234_ sky130_fd_sc_hd__clkbuf_1
X_2154_ clknet_leaf_2_clk _0234_ _0064_ VGND VGND VPWR VPWR dual_watchdog_inst.watchdog_fc.rising_edge_timeout.assert_time\[7\]
+ sky130_fd_sc_hd__dfrtp_1
X_2223_ clknet_leaf_22_clk _0008_ net14 VGND VGND VPWR VPWR dual_watchdog_inst.watchdog_fc.falling_edge_timeout.internal_count\[14\]
+ sky130_fd_sc_hd__dfrtp_2
XFILLER_0_17_83 VGND VGND VPWR VPWR sky130_fd_sc_hd__fill_1
XFILLER_0_48_326 VGND VGND VPWR VPWR sky130_fd_sc_hd__decap_3
X_1036_ net25 _0726_ _0738_ VGND VGND VPWR VPWR _0001_ sky130_fd_sc_hd__nand3_1
X_1869_ _0624_ _0625_ _0609_ VGND VGND VPWR VPWR _0282_ sky130_fd_sc_hd__a21oi_1
X_1938_ _0821_ _0653_ _0654_ VGND VGND VPWR VPWR _0295_ sky130_fd_sc_hd__nor3_1
XFILLER_0_16_267 VPWR VGND VPWR VGND sky130_ef_sc_hd__decap_12
XFILLER_0_38_27 VGND VGND VPWR VPWR sky130_fd_sc_hd__fill_1
XFILLER_0_54_26 VGND VGND VPWR VPWR sky130_fd_sc_hd__fill_2
XFILLER_0_54_15 VGND VGND VPWR VPWR sky130_fd_sc_hd__decap_4
XFILLER_0_45_307 VGND VGND VPWR VPWR sky130_fd_sc_hd__decap_4
Xhold116 uart_rx_raspi_inst.data_reg\[0\] VGND VGND VPWR VPWR net130 sky130_fd_sc_hd__dlygate4sd3_1
Xhold127 uart_tx_jetson_inst.data_reg\[5\] VGND VGND VPWR VPWR net141 sky130_fd_sc_hd__dlygate4sd3_1
Xhold149 uart_tx_jetson_inst.data_reg\[0\] VGND VGND VPWR VPWR net163 sky130_fd_sc_hd__dlygate4sd3_1
Xhold105 dual_watchdog_inst.watchdog_fc.rising_edge_timeout.assert_time\[11\] VGND
+ VGND VPWR VPWR net119 sky130_fd_sc_hd__dlygate4sd3_1
X_1723_ uart_rx_jetson_inst.prescale_reg\[9\] _0540_ uart_rx_jetson_inst.prescale_reg\[10\]
+ VGND VGND VPWR VPWR _0544_ sky130_fd_sc_hd__o21a_1
XFILLER_0_13_215 VGND VGND VPWR VPWR sky130_fd_sc_hd__decap_8
XFILLER_0_13_237 VGND VGND VPWR VPWR sky130_fd_sc_hd__decap_4
Xhold138 dual_watchdog_inst.watchdog_fc.falling_edge_timeout.assert_time\[21\] VGND
+ VGND VPWR VPWR net152 sky130_fd_sc_hd__dlygate4sd3_1
X_1654_ _0491_ VGND VGND VPWR VPWR _0201_ sky130_fd_sc_hd__clkbuf_1
XTAP_487 VGND VPWR sky130_fd_sc_hd__tapvpwrvgnd_1
XTAP_498 VGND VPWR sky130_fd_sc_hd__tapvpwrvgnd_1
XTAP_476 VGND VPWR sky130_fd_sc_hd__tapvpwrvgnd_1
XTAP_465 VGND VPWR sky130_fd_sc_hd__tapvpwrvgnd_1
XTAP_454 VGND VPWR sky130_fd_sc_hd__tapvpwrvgnd_1
XTAP_443 VGND VPWR sky130_fd_sc_hd__tapvpwrvgnd_1
XTAP_432 VGND VPWR sky130_fd_sc_hd__tapvpwrvgnd_1
XTAP_421 VGND VPWR sky130_fd_sc_hd__tapvpwrvgnd_1
XTAP_410 VGND VPWR sky130_fd_sc_hd__tapvpwrvgnd_1
X_1585_ _1009_ _0444_ VGND VGND VPWR VPWR _0179_ sky130_fd_sc_hd__nor2_1
XFILLER_0_28_60 VGND VGND VPWR VPWR sky130_fd_sc_hd__decap_4
XFILLER_0_0_153 VGND VGND VPWR VPWR sky130_fd_sc_hd__decap_4
XFILLER_0_0_197 VPWR VGND VPWR VGND sky130_ef_sc_hd__decap_12
XFILLER_0_21_281 VGND VGND VPWR VPWR sky130_fd_sc_hd__decap_6
X_2206_ clknet_leaf_19_clk _0286_ VGND VGND VPWR VPWR uart_tx_raspi_inst.bit_cnt\[1\]
+ sky130_fd_sc_hd__dfxtp_1
X_1019_ dual_watchdog_inst.watchdog_fc.rising_edge_timeout.assert_time\[20\] dual_watchdog_inst.watchdog_fc.rising_edge_timeout.assert_time\[19\]
+ dual_watchdog_inst.watchdog_fc.rising_edge_timeout.assert_time\[18\] dual_watchdog_inst.watchdog_fc.rising_edge_timeout.assert_time\[17\]
+ VGND VGND VPWR VPWR _0722_ sky130_fd_sc_hd__or4_1
XFILLER_0_14_3 VGND VGND VPWR VPWR sky130_fd_sc_hd__decap_6
X_2137_ clknet_leaf_20_clk _0217_ VGND VGND VPWR VPWR uart_rx_jetson_inst.prescale_reg\[9\]
+ sky130_fd_sc_hd__dfxtp_1
X_2068_ clknet_leaf_24_clk net56 VGND VGND VPWR VPWR uart_rx_raspi_inst.prescale_reg\[15\]
+ sky130_fd_sc_hd__dfxtp_1
XFILLER_0_48_189 VGND VGND VPWR VPWR sky130_fd_sc_hd__fill_1
XFILLER_0_36_307 VGND VGND VPWR VPWR sky130_fd_sc_hd__fill_1
XFILLER_0_12_292 VPWR VGND VPWR VGND sky130_ef_sc_hd__decap_12
XFILLER_0_39_189 VGND VGND VPWR VPWR sky130_fd_sc_hd__fill_1
XFILLER_0_24_29 VGND VGND VPWR VPWR sky130_fd_sc_hd__decap_6
XFILLER_0_50_354 VGND VGND VPWR VPWR sky130_fd_sc_hd__decap_8
X_1370_ _0964_ _0978_ VGND VGND VPWR VPWR _0979_ sky130_fd_sc_hd__and2b_1
XFILLER_0_5_201 VPWR VGND VPWR VGND sky130_ef_sc_hd__decap_12
XFILLER_0_18_329 VGND VGND VPWR VPWR sky130_fd_sc_hd__decap_3
X_1637_ uart_rx_jetson_inst.m_axis_tdata_reg\[0\] net155 _0479_ VGND VGND VPWR VPWR
+ _0480_ sky130_fd_sc_hd__mux2_1
XFILLER_0_5_289 VGND VGND VPWR VPWR sky130_fd_sc_hd__decap_4
X_1706_ uart_rx_jetson_inst.prescale_reg\[4\] _0469_ uart_rx_jetson_inst.prescale_reg\[5\]
+ VGND VGND VPWR VPWR _0532_ sky130_fd_sc_hd__o21ai_1
X_1568_ net60 _0431_ VGND VGND VPWR VPWR _0433_ sky130_fd_sc_hd__or2_1
X_1499_ _0371_ VGND VGND VPWR VPWR _0383_ sky130_fd_sc_hd__clkbuf_4
XTAP_295 VGND VPWR sky130_fd_sc_hd__tapvpwrvgnd_1
XTAP_284 VGND VPWR sky130_fd_sc_hd__tapvpwrvgnd_1
XTAP_240 VGND VPWR sky130_fd_sc_hd__tapvpwrvgnd_1
XTAP_251 VGND VPWR sky130_fd_sc_hd__tapvpwrvgnd_1
XTAP_262 VGND VPWR sky130_fd_sc_hd__tapvpwrvgnd_1
XTAP_273 VGND VPWR sky130_fd_sc_hd__tapvpwrvgnd_1
XFILLER_0_36_126 VPWR VGND VPWR VGND sky130_ef_sc_hd__decap_12
Xfanout11 net14 VGND VGND VPWR VPWR net11 sky130_fd_sc_hd__clkbuf_4
XFILLER_0_36_148 VPWR VGND VPWR VGND sky130_ef_sc_hd__decap_12
XFILLER_0_32_321 VPWR VGND VPWR VGND sky130_ef_sc_hd__decap_12
XFILLER_0_3_3 VPWR VGND VPWR VGND sky130_ef_sc_hd__decap_12
XFILLER_0_35_39 VGND VGND VPWR VPWR sky130_fd_sc_hd__decap_8
XFILLER_0_51_38 VGND VGND VPWR VPWR sky130_fd_sc_hd__fill_1
XFILLER_0_50_151 VPWR VGND VPWR VGND sky130_ef_sc_hd__decap_12
X_1422_ _1001_ _0327_ _0963_ VGND VGND VPWR VPWR _0328_ sky130_fd_sc_hd__a21o_2
X_1284_ dual_watchdog_inst.watchdog_fc.rising_edge_timeout.internal_count\[21\] dual_watchdog_inst.watchdog_fc.rising_edge_timeout.internal_count\[20\]
+ VGND VGND VPWR VPWR _0910_ sky130_fd_sc_hd__nand2_1
X_1353_ _0962_ VGND VGND VPWR VPWR _0120_ sky130_fd_sc_hd__clkbuf_1
XFILLER_0_25_72 VPWR VGND VPWR VGND sky130_ef_sc_hd__decap_12
XFILLER_0_58_295 VPWR VGND VPWR VGND sky130_ef_sc_hd__decap_12
XFILLER_0_14_343 VGND VGND VPWR VPWR sky130_fd_sc_hd__decap_3
XFILLER_0_5_60 VGND VGND VPWR VPWR sky130_fd_sc_hd__decap_3
XFILLER_0_1_281 VPWR VGND VPWR VGND sky130_ef_sc_hd__decap_12
XFILLER_0_20_313 VGND VGND VPWR VPWR sky130_fd_sc_hd__fill_1
XFILLER_0_20_335 VGND VGND VPWR VPWR sky130_fd_sc_hd__fill_1
XFILLER_0_55_298 VPWR VGND VPWR VGND sky130_ef_sc_hd__decap_12
XFILLER_0_11_30 VPWR VGND VPWR VGND sky130_ef_sc_hd__decap_12
X_1971_ net221 _0676_ _0677_ _0841_ VGND VGND VPWR VPWR _0305_ sky130_fd_sc_hd__o211a_1
X_1405_ uart_rx_raspi_inst.rxd_reg _0997_ _1003_ _1004_ VGND VGND VPWR VPWR _1005_
+ sky130_fd_sc_hd__a22o_1
XFILLER_0_11_335 VGND VGND VPWR VPWR sky130_fd_sc_hd__fill_1
X_1267_ dual_watchdog_inst.watchdog_fc.rising_edge_timeout.internal_count\[15\] dual_watchdog_inst.watchdog_fc.rising_edge_timeout.internal_count\[14\]
+ _0895_ VGND VGND VPWR VPWR _0899_ sky130_fd_sc_hd__and3_1
Xinput1 heartbeat_fc VGND VGND VPWR VPWR net1 sky130_fd_sc_hd__dlymetal6s2s_1
X_1198_ net114 _0853_ VGND VGND VPWR VPWR _0012_ sky130_fd_sc_hd__xor2_1
X_1336_ uart_rx_jetson_inst.m_axis_tdata_reg\[3\] uart_tx_raspi_inst.data_reg\[4\]
+ _0930_ VGND VGND VPWR VPWR _0951_ sky130_fd_sc_hd__mux2_1
XFILLER_0_52_81 VGND VGND VPWR VPWR sky130_fd_sc_hd__decap_3
XFILLER_0_46_243 VGND VGND VPWR VPWR sky130_fd_sc_hd__decap_6
XFILLER_0_14_151 VGND VGND VPWR VPWR sky130_fd_sc_hd__fill_1
XFILLER_0_14_195 VGND VGND VPWR VPWR sky130_fd_sc_hd__fill_1
XFILLER_0_52_224 VPWR VGND VPWR VGND sky130_ef_sc_hd__decap_12
XFILLER_0_37_210 VGND VGND VPWR VPWR sky130_fd_sc_hd__fill_2
X_2170_ clknet_leaf_3_clk _0250_ _0080_ VGND VGND VPWR VPWR dual_watchdog_inst.watchdog_fc.rising_edge_timeout.assert_time\[23\]
+ sky130_fd_sc_hd__dfrtp_1
X_1052_ _0753_ VGND VGND VPWR VPWR _0253_ sky130_fd_sc_hd__clkbuf_1
X_1121_ _0759_ _0796_ VGND VGND VPWR VPWR _0227_ sky130_fd_sc_hd__nor2_1
XFILLER_0_7_137 VGND VGND VPWR VPWR sky130_fd_sc_hd__fill_2
X_1954_ _0665_ VGND VGND VPWR VPWR _0666_ sky130_fd_sc_hd__clkbuf_2
XFILLER_0_28_298 VGND VGND VPWR VPWR sky130_fd_sc_hd__decap_8
X_1885_ _0961_ _0635_ VGND VGND VPWR VPWR _0636_ sky130_fd_sc_hd__nand2_1
XFILLER_0_22_62 VGND VGND VPWR VPWR sky130_fd_sc_hd__fill_1
XFILLER_0_44_3 VGND VGND VPWR VPWR sky130_fd_sc_hd__decap_4
XPHY_116 VGND VGND VPWR VPWR sky130_fd_sc_hd__decap_3
XPHY_105 VGND VGND VPWR VPWR sky130_fd_sc_hd__decap_3
X_1319_ uart_tx_raspi_inst.prescale_reg\[15\] uart_tx_raspi_inst.prescale_reg\[14\]
+ uart_tx_raspi_inst.prescale_reg\[13\] VGND VGND VPWR VPWR _0937_ sky130_fd_sc_hd__or3_1
XFILLER_0_2_83 VGND VGND VPWR VPWR sky130_fd_sc_hd__fill_1
X_2299_ clknet_leaf_23_clk _0323_ VGND VGND VPWR VPWR uart_rx_jetson_inst.data_reg\[7\]
+ sky130_fd_sc_hd__dfxtp_1
XFILLER_0_19_276 VGND VGND VPWR VPWR sky130_fd_sc_hd__decap_4
XFILLER_0_6_192 VGND VGND VPWR VPWR sky130_fd_sc_hd__decap_4
XFILLER_0_57_349 VPWR VGND VPWR VGND sky130_ef_sc_hd__decap_12
XFILLER_0_57_305 VPWR VGND VPWR VGND sky130_ef_sc_hd__decap_12
XPHY_7 VGND VGND VPWR VPWR sky130_fd_sc_hd__decap_3
XFILLER_0_33_290 VGND VGND VPWR VPWR sky130_fd_sc_hd__fill_1
X_1670_ _0496_ _0502_ _0503_ _0504_ _1002_ VGND VGND VPWR VPWR _0204_ sky130_fd_sc_hd__a221oi_1
X_2222_ clknet_leaf_22_clk _0007_ net11 VGND VGND VPWR VPWR dual_watchdog_inst.watchdog_fc.falling_edge_timeout.internal_count\[13\]
+ sky130_fd_sc_hd__dfrtp_1
XFILLER_0_0_335 VGND VGND VPWR VPWR sky130_fd_sc_hd__fill_1
X_1035_ _0737_ VGND VGND VPWR VPWR _0738_ sky130_fd_sc_hd__buf_2
X_2084_ clknet_leaf_12_clk _0164_ VGND VGND VPWR VPWR uart_tx_jetson_inst.prescale_reg\[7\]
+ sky130_fd_sc_hd__dfxtp_1
X_1104_ _0742_ _0766_ _0786_ VGND VGND VPWR VPWR _0787_ sky130_fd_sc_hd__and3b_1
X_2153_ clknet_leaf_0_clk _0233_ _0063_ VGND VGND VPWR VPWR dual_watchdog_inst.watchdog_fc.rising_edge_timeout.assert_time\[6\]
+ sky130_fd_sc_hd__dfrtp_1
X_1937_ dual_watchdog_inst.watchdog_fc.falling_edge_timeout.assert_time\[6\] _0645_
+ _0651_ VGND VGND VPWR VPWR _0654_ sky130_fd_sc_hd__and3_1
X_1799_ _0577_ net139 _0571_ VGND VGND VPWR VPWR _0578_ sky130_fd_sc_hd__mux2_1
X_1868_ net100 _0938_ VGND VGND VPWR VPWR _0625_ sky130_fd_sc_hd__nand2_1
Xhold117 dual_watchdog_inst.watchdog_fc.rising_edge_timeout.internal_count\[10\] VGND
+ VGND VPWR VPWR net131 sky130_fd_sc_hd__dlygate4sd3_1
XTAP_400 VGND VPWR sky130_fd_sc_hd__tapvpwrvgnd_1
Xhold106 dual_watchdog_inst.watchdog_fc.rising_edge_timeout.internal_count\[25\] VGND
+ VGND VPWR VPWR net120 sky130_fd_sc_hd__dlygate4sd3_1
Xhold128 uart_tx_raspi_inst.prescale_reg\[13\] VGND VGND VPWR VPWR net142 sky130_fd_sc_hd__dlygate4sd3_1
X_1584_ uart_tx_jetson_inst.bit_cnt\[3\] _0443_ _0436_ _0369_ VGND VGND VPWR VPWR
+ _0444_ sky130_fd_sc_hd__o2bb2a_1
Xhold139 dual_watchdog_inst.watchdog_fc.falling_edge_timeout.assert_time\[11\] VGND
+ VGND VPWR VPWR net153 sky130_fd_sc_hd__dlygate4sd3_1
X_1722_ uart_rx_jetson_inst.prescale_reg\[10\] uart_rx_jetson_inst.prescale_reg\[9\]
+ _0540_ VGND VGND VPWR VPWR _0543_ sky130_fd_sc_hd__nor3_1
X_1653_ _1008_ _0490_ VGND VGND VPWR VPWR _0491_ sky130_fd_sc_hd__and2b_1
XTAP_499 VGND VPWR sky130_fd_sc_hd__tapvpwrvgnd_1
XTAP_488 VGND VPWR sky130_fd_sc_hd__tapvpwrvgnd_1
XTAP_477 VGND VPWR sky130_fd_sc_hd__tapvpwrvgnd_1
XTAP_466 VGND VPWR sky130_fd_sc_hd__tapvpwrvgnd_1
XTAP_455 VGND VPWR sky130_fd_sc_hd__tapvpwrvgnd_1
XTAP_444 VGND VPWR sky130_fd_sc_hd__tapvpwrvgnd_1
XTAP_433 VGND VPWR sky130_fd_sc_hd__tapvpwrvgnd_1
XTAP_422 VGND VPWR sky130_fd_sc_hd__tapvpwrvgnd_1
XTAP_411 VGND VPWR sky130_fd_sc_hd__tapvpwrvgnd_1
XFILLER_0_28_83 VGND VGND VPWR VPWR sky130_fd_sc_hd__fill_1
X_2205_ clknet_leaf_19_clk _0285_ VGND VGND VPWR VPWR uart_tx_raspi_inst.bit_cnt\[0\]
+ sky130_fd_sc_hd__dfxtp_1
X_1018_ _0718_ _0719_ _0720_ VGND VGND VPWR VPWR _0721_ sky130_fd_sc_hd__or3_1
X_2067_ clknet_leaf_0_clk _0147_ VGND VGND VPWR VPWR uart_rx_raspi_inst.prescale_reg\[14\]
+ sky130_fd_sc_hd__dfxtp_1
X_2136_ clknet_leaf_20_clk _0216_ VGND VGND VPWR VPWR uart_rx_jetson_inst.prescale_reg\[8\]
+ sky130_fd_sc_hd__dfxtp_1
XFILLER_0_44_352 VGND VGND VPWR VPWR sky130_fd_sc_hd__decap_8
XFILLER_0_8_82 VGND VGND VPWR VPWR sky130_fd_sc_hd__fill_2
XFILLER_0_8_93 VGND VGND VPWR VPWR sky130_fd_sc_hd__decap_4
XFILLER_0_12_271 VGND VGND VPWR VPWR sky130_fd_sc_hd__decap_4
XFILLER_0_54_105 VGND VGND VPWR VPWR sky130_fd_sc_hd__fill_1
XFILLER_0_39_113 VGND VGND VPWR VPWR sky130_fd_sc_hd__decap_8
XFILLER_0_50_300 VGND VGND VPWR VPWR sky130_fd_sc_hd__decap_8
XFILLER_0_4_29 VGND VGND VPWR VPWR sky130_fd_sc_hd__fill_1
XFILLER_0_14_41 VGND VGND VPWR VPWR sky130_fd_sc_hd__decap_6
XFILLER_0_14_52 VGND VGND VPWR VPWR sky130_fd_sc_hd__decap_4
XFILLER_0_45_127 VGND VGND VPWR VPWR sky130_fd_sc_hd__fill_1
XFILLER_0_41_311 VGND VGND VPWR VPWR sky130_fd_sc_hd__decap_8
XFILLER_0_30_62 VGND VGND VPWR VPWR sky130_fd_sc_hd__fill_1
XFILLER_0_5_279 VGND VGND VPWR VPWR sky130_fd_sc_hd__fill_1
XFILLER_0_5_213 VGND VGND VPWR VPWR sky130_fd_sc_hd__decap_8
X_1705_ uart_rx_jetson_inst.prescale_reg\[5\] uart_rx_jetson_inst.prescale_reg\[4\]
+ _0469_ VGND VGND VPWR VPWR _0531_ sky130_fd_sc_hd__or3_1
X_1567_ _0431_ _0432_ _0414_ VGND VGND VPWR VPWR _0173_ sky130_fd_sc_hd__a21oi_1
XFILLER_0_39_71 VGND VGND VPWR VPWR sky130_fd_sc_hd__decap_8
XTAP_230 VGND VPWR sky130_fd_sc_hd__tapvpwrvgnd_1
X_1636_ _0478_ VGND VGND VPWR VPWR _0479_ sky130_fd_sc_hd__clkbuf_4
XTAP_241 VGND VPWR sky130_fd_sc_hd__tapvpwrvgnd_1
XFILLER_0_55_81 VGND VGND VPWR VPWR sky130_fd_sc_hd__fill_1
X_1498_ _0382_ VGND VGND VPWR VPWR _0154_ sky130_fd_sc_hd__clkbuf_1
XTAP_296 VGND VPWR sky130_fd_sc_hd__tapvpwrvgnd_1
XTAP_285 VGND VPWR sky130_fd_sc_hd__tapvpwrvgnd_1
X_2119_ clknet_leaf_17_clk _0199_ VGND VGND VPWR VPWR uart_rx_jetson_inst.m_axis_tdata_reg\[3\]
+ sky130_fd_sc_hd__dfxtp_1
XTAP_252 VGND VPWR sky130_fd_sc_hd__tapvpwrvgnd_1
XTAP_263 VGND VPWR sky130_fd_sc_hd__tapvpwrvgnd_1
XTAP_274 VGND VPWR sky130_fd_sc_hd__tapvpwrvgnd_1
XFILLER_0_36_138 VGND VGND VPWR VPWR sky130_fd_sc_hd__fill_2
XFILLER_0_36_116 VGND VGND VPWR VPWR sky130_fd_sc_hd__decap_6
Xfanout12 net14 VGND VGND VPWR VPWR net12 sky130_fd_sc_hd__clkbuf_4
XFILLER_0_32_333 VPWR VGND VPWR VGND sky130_ef_sc_hd__decap_12
XFILLER_0_50_163 VGND VGND VPWR VPWR sky130_fd_sc_hd__decap_6
X_1421_ uart_rx_raspi_inst.rxd_reg uart_rx_raspi_inst.bit_cnt\[0\] _0973_ VGND VGND
+ VPWR VPWR _0327_ sky130_fd_sc_hd__o21ba_1
X_1283_ net226 _0908_ _0909_ VGND VGND VPWR VPWR _0042_ sky130_fd_sc_hd__o21ba_1
X_1352_ _0961_ net162 net15 VGND VGND VPWR VPWR _0962_ sky130_fd_sc_hd__mux2_2
XFILLER_0_25_84 VGND VGND VPWR VPWR sky130_fd_sc_hd__decap_3
XFILLER_0_26_193 VGND VGND VPWR VPWR sky130_fd_sc_hd__decap_3
XFILLER_0_14_333 VGND VGND VPWR VPWR sky130_fd_sc_hd__decap_6
X_1619_ _0464_ net168 _0454_ VGND VGND VPWR VPWR _0465_ sky130_fd_sc_hd__mux2_1
XFILLER_0_5_83 VGND VGND VPWR VPWR sky130_fd_sc_hd__decap_4
XFILLER_0_1_293 VPWR VGND VPWR VGND sky130_ef_sc_hd__decap_12
XFILLER_0_49_274 VGND VGND VPWR VPWR sky130_fd_sc_hd__decap_6
X_1970_ dual_watchdog_inst.watchdog_fc.falling_edge_timeout.assert_time\[16\] _0676_
+ VGND VGND VPWR VPWR _0677_ sky130_fd_sc_hd__nand2_1
XFILLER_0_11_42 VPWR VGND VPWR VGND sky130_ef_sc_hd__decap_12
XFILLER_0_15_108 VGND VGND VPWR VPWR sky130_fd_sc_hd__decap_4
X_1404_ uart_rx_raspi_inst.bit_cnt\[1\] uart_rx_raspi_inst.bit_cnt\[0\] VGND VGND
+ VPWR VPWR _1004_ sky130_fd_sc_hd__nand2_1
X_1335_ _0950_ VGND VGND VPWR VPWR _0114_ sky130_fd_sc_hd__clkbuf_1
XFILLER_0_11_325 VGND VGND VPWR VPWR sky130_fd_sc_hd__fill_2
X_1266_ net217 _0896_ VGND VGND VPWR VPWR _0898_ sky130_fd_sc_hd__nor2_1
XFILLER_0_36_83 VGND VGND VPWR VPWR sky130_fd_sc_hd__fill_1
Xinput2 rxd_jetson VGND VGND VPWR VPWR net2 sky130_fd_sc_hd__clkbuf_1
X_1197_ _0821_ _0851_ _0853_ VGND VGND VPWR VPWR _0011_ sky130_fd_sc_hd__nor3_1
XFILLER_0_32_19 VGND VGND VPWR VPWR sky130_fd_sc_hd__fill_1
X_1051_ _0738_ _0751_ _0752_ VGND VGND VPWR VPWR _0753_ sky130_fd_sc_hd__and3_1
X_1120_ net223 _0796_ _0794_ _0738_ VGND VGND VPWR VPWR _0228_ sky130_fd_sc_hd__o211a_1
X_1953_ dual_watchdog_inst.watchdog_fc.falling_edge_timeout.assert_time\[11\] dual_watchdog_inst.watchdog_fc.falling_edge_timeout.assert_time\[10\]
+ _0655_ _0661_ VGND VGND VPWR VPWR _0665_ sky130_fd_sc_hd__and4_1
X_1884_ net240 _0941_ VGND VGND VPWR VPWR _0635_ sky130_fd_sc_hd__nor2_1
XFILLER_0_22_85 VGND VGND VPWR VPWR sky130_fd_sc_hd__fill_1
XFILLER_0_37_3 VGND VGND VPWR VPWR sky130_fd_sc_hd__decap_6
X_1318_ uart_tx_raspi_inst.prescale_reg\[8\] _0933_ _0934_ _0935_ VGND VGND VPWR VPWR
+ _0936_ sky130_fd_sc_hd__or4_4
XFILLER_0_11_188 VPWR VGND VPWR VGND sky130_ef_sc_hd__decap_12
X_2298_ clknet_leaf_23_clk _0322_ VGND VGND VPWR VPWR uart_rx_jetson_inst.data_reg\[6\]
+ sky130_fd_sc_hd__dfxtp_1
XPHY_117 VGND VGND VPWR VPWR sky130_fd_sc_hd__decap_3
X_1249_ dual_watchdog_inst.watchdog_fc.rising_edge_timeout.internal_count\[9\] dual_watchdog_inst.watchdog_fc.rising_edge_timeout.internal_count\[8\]
+ VGND VGND VPWR VPWR _0886_ sky130_fd_sc_hd__and2_1
XPHY_106 VGND VGND VPWR VPWR sky130_fd_sc_hd__decap_3
XFILLER_0_19_255 VGND VGND VPWR VPWR sky130_fd_sc_hd__fill_2
XFILLER_0_19_266 VGND VGND VPWR VPWR sky130_fd_sc_hd__fill_1
XFILLER_0_42_291 VPWR VGND VPWR VGND sky130_ef_sc_hd__decap_12
XFILLER_0_57_317 VPWR VGND VPWR VGND sky130_ef_sc_hd__decap_12
XPHY_8 VGND VGND VPWR VPWR sky130_fd_sc_hd__decap_3
X_2152_ clknet_leaf_30_clk _0232_ _0062_ VGND VGND VPWR VPWR dual_watchdog_inst.watchdog_fc.rising_edge_timeout.assert_time\[5\]
+ sky130_fd_sc_hd__dfrtp_1
X_2221_ clknet_leaf_25_clk _0006_ net11 VGND VGND VPWR VPWR dual_watchdog_inst.watchdog_fc.falling_edge_timeout.internal_count\[12\]
+ sky130_fd_sc_hd__dfrtp_1
XFILLER_0_17_30 VPWR VGND VPWR VGND sky130_ef_sc_hd__decap_12
X_2083_ clknet_leaf_12_clk _0163_ VGND VGND VPWR VPWR uart_tx_jetson_inst.prescale_reg\[6\]
+ sky130_fd_sc_hd__dfxtp_1
X_1034_ _0731_ _0734_ _0735_ _0736_ VGND VGND VPWR VPWR _0737_ sky130_fd_sc_hd__or4_2
XFILLER_0_33_51 VGND VGND VPWR VPWR sky130_fd_sc_hd__decap_4
X_1103_ dual_watchdog_inst.watchdog_fc.rising_edge_timeout.assert_time\[7\] _0785_
+ VGND VGND VPWR VPWR _0786_ sky130_fd_sc_hd__or2_1
XFILLER_0_56_361 VGND VGND VPWR VPWR sky130_fd_sc_hd__fill_1
X_1867_ uart_tx_raspi_inst.prescale_reg\[16\] _0938_ VGND VGND VPWR VPWR _0624_ sky130_fd_sc_hd__or2_1
X_1936_ _0645_ _0651_ net216 VGND VGND VPWR VPWR _0653_ sky130_fd_sc_hd__a21oi_1
XFILLER_0_16_258 VGND VGND VPWR VPWR sky130_fd_sc_hd__fill_2
X_1798_ uart_rx_raspi_inst.m_axis_tdata_reg\[3\] uart_tx_jetson_inst.data_reg\[4\]
+ _0383_ VGND VGND VPWR VPWR _0577_ sky130_fd_sc_hd__mux2_1
XFILLER_0_47_361 VGND VGND VPWR VPWR sky130_fd_sc_hd__fill_1
XFILLER_0_57_169 VGND VGND VPWR VPWR sky130_fd_sc_hd__decap_8
X_1721_ _0504_ _0501_ _0520_ _0542_ VGND VGND VPWR VPWR _0217_ sky130_fd_sc_hd__a211oi_1
Xhold118 uart_tx_jetson_inst.data_reg\[2\] VGND VGND VPWR VPWR net132 sky130_fd_sc_hd__dlygate4sd3_1
XTAP_423 VGND VPWR sky130_fd_sc_hd__tapvpwrvgnd_1
XTAP_412 VGND VPWR sky130_fd_sc_hd__tapvpwrvgnd_1
Xhold107 _0047_ VGND VGND VPWR VPWR net121 sky130_fd_sc_hd__dlygate4sd3_1
XTAP_401 VGND VPWR sky130_fd_sc_hd__tapvpwrvgnd_1
X_1583_ uart_tx_jetson_inst.bit_cnt\[2\] uart_tx_jetson_inst.bit_cnt\[1\] _0436_ VGND
+ VGND VPWR VPWR _0443_ sky130_fd_sc_hd__or3_1
X_1652_ uart_rx_jetson_inst.m_axis_tdata_reg\[5\] uart_rx_jetson_inst.data_reg\[5\]
+ _0479_ VGND VGND VPWR VPWR _0490_ sky130_fd_sc_hd__mux2_1
Xhold129 dual_watchdog_inst.watchdog_fc.falling_edge_timeout.internal_count\[25\]
+ VGND VGND VPWR VPWR net143 sky130_fd_sc_hd__dlygate4sd3_1
XTAP_489 VGND VPWR sky130_fd_sc_hd__tapvpwrvgnd_1
XTAP_478 VGND VPWR sky130_fd_sc_hd__tapvpwrvgnd_1
XTAP_467 VGND VPWR sky130_fd_sc_hd__tapvpwrvgnd_1
XTAP_456 VGND VPWR sky130_fd_sc_hd__tapvpwrvgnd_1
XTAP_445 VGND VPWR sky130_fd_sc_hd__tapvpwrvgnd_1
XTAP_434 VGND VPWR sky130_fd_sc_hd__tapvpwrvgnd_1
X_2204_ clknet_leaf_16_clk _0284_ VGND VGND VPWR VPWR uart_tx_raspi_inst.prescale_reg\[18\]
+ sky130_fd_sc_hd__dfxtp_1
X_2135_ clknet_leaf_21_clk _0215_ VGND VGND VPWR VPWR uart_rx_jetson_inst.prescale_reg\[7\]
+ sky130_fd_sc_hd__dfxtp_1
XFILLER_0_44_83 VGND VGND VPWR VPWR sky130_fd_sc_hd__fill_1
XFILLER_0_36_309 VGND VGND VPWR VPWR sky130_fd_sc_hd__fill_2
X_1017_ dual_watchdog_inst.watchdog_fc.rising_edge_timeout.assert_time\[12\] dual_watchdog_inst.watchdog_fc.rising_edge_timeout.assert_time\[11\]
+ dual_watchdog_inst.watchdog_fc.rising_edge_timeout.assert_time\[10\] dual_watchdog_inst.watchdog_fc.rising_edge_timeout.assert_time\[9\]
+ VGND VGND VPWR VPWR _0720_ sky130_fd_sc_hd__or4_1
X_2066_ clknet_leaf_0_clk _0146_ VGND VGND VPWR VPWR uart_rx_raspi_inst.prescale_reg\[13\]
+ sky130_fd_sc_hd__dfxtp_1
XFILLER_0_8_233 VPWR VGND VPWR VGND sky130_ef_sc_hd__decap_12
XFILLER_0_60_82 VGND VGND VPWR VPWR sky130_fd_sc_hd__fill_2
X_1919_ _0829_ _0002_ _0640_ VGND VGND VPWR VPWR _0641_ sky130_fd_sc_hd__and3_1
XFILLER_0_12_250 VGND VGND VPWR VPWR sky130_fd_sc_hd__fill_2
XFILLER_0_27_309 VGND VGND VPWR VPWR sky130_fd_sc_hd__decap_8
XFILLER_0_50_312 VGND VGND VPWR VPWR sky130_fd_sc_hd__decap_4
XFILLER_0_45_117 VGND VGND VPWR VPWR sky130_fd_sc_hd__fill_1
XFILLER_0_18_309 VPWR VGND VPWR VGND sky130_ef_sc_hd__decap_12
XFILLER_0_60_109 VGND VGND VPWR VPWR sky130_fd_sc_hd__decap_3
XFILLER_0_41_334 VGND VGND VPWR VPWR sky130_fd_sc_hd__fill_2
XFILLER_0_30_85 VPWR VGND VPWR VGND sky130_ef_sc_hd__decap_12
XFILLER_0_26_342 VGND VGND VPWR VPWR sky130_fd_sc_hd__decap_4
X_1704_ _0520_ _0530_ VGND VGND VPWR VPWR _0212_ sky130_fd_sc_hd__nor2_1
X_1566_ _0372_ _0425_ net79 VGND VGND VPWR VPWR _0432_ sky130_fd_sc_hd__o21ai_1
X_1497_ _1008_ _0381_ VGND VGND VPWR VPWR _0382_ sky130_fd_sc_hd__or2_1
XTAP_220 VGND VPWR sky130_fd_sc_hd__tapvpwrvgnd_1
X_1635_ uart_rx_jetson_inst.rxd_reg _0475_ _0476_ _0477_ VGND VGND VPWR VPWR _0478_
+ sky130_fd_sc_hd__and4_1
XTAP_231 VGND VPWR sky130_fd_sc_hd__tapvpwrvgnd_1
XTAP_242 VGND VPWR sky130_fd_sc_hd__tapvpwrvgnd_1
XTAP_253 VGND VPWR sky130_fd_sc_hd__tapvpwrvgnd_1
XTAP_264 VGND VPWR sky130_fd_sc_hd__tapvpwrvgnd_1
XTAP_275 VGND VPWR sky130_fd_sc_hd__tapvpwrvgnd_1
X_2049_ clknet_leaf_9_clk _0129_ VGND VGND VPWR VPWR uart_rx_raspi_inst.bit_cnt\[0\]
+ sky130_fd_sc_hd__dfxtp_1
X_2118_ clknet_leaf_17_clk _0198_ VGND VGND VPWR VPWR uart_rx_jetson_inst.m_axis_tdata_reg\[2\]
+ sky130_fd_sc_hd__dfxtp_1
XTAP_297 VGND VPWR sky130_fd_sc_hd__tapvpwrvgnd_1
XTAP_286 VGND VPWR sky130_fd_sc_hd__tapvpwrvgnd_1
Xfanout13 net14 VGND VGND VPWR VPWR net13 sky130_fd_sc_hd__clkbuf_2
XFILLER_0_32_345 VPWR VGND VPWR VGND sky130_ef_sc_hd__decap_12
XFILLER_0_50_120 VGND VGND VPWR VPWR sky130_fd_sc_hd__decap_4
X_1420_ net209 _1001_ VGND VGND VPWR VPWR _0326_ sky130_fd_sc_hd__or2_1
X_1351_ uart_tx_raspi_inst.bit_cnt\[0\] _0942_ VGND VGND VPWR VPWR _0961_ sky130_fd_sc_hd__and2b_1
X_1282_ dual_watchdog_inst.watchdog_fc.rising_edge_timeout.internal_count\[19\] dual_watchdog_inst.watchdog_fc.rising_edge_timeout.internal_count\[20\]
+ _0906_ _0758_ VGND VGND VPWR VPWR _0909_ sky130_fd_sc_hd__a31o_1
X_1618_ uart_rx_raspi_inst.data_reg\[6\] _0974_ VGND VGND VPWR VPWR _0464_ sky130_fd_sc_hd__and2_1
X_1549_ uart_rst _0419_ _0420_ VGND VGND VPWR VPWR _0421_ sky130_fd_sc_hd__and3b_1
XFILLER_0_49_220 VGND VGND VPWR VPWR sky130_fd_sc_hd__decap_4
XFILLER_0_32_120 VPWR VGND VPWR VGND sky130_ef_sc_hd__decap_12
XFILLER_0_9_361 VGND VGND VPWR VPWR sky130_fd_sc_hd__fill_1
XFILLER_0_32_153 VGND VGND VPWR VPWR sky130_fd_sc_hd__fill_1
XFILLER_0_20_304 VGND VGND VPWR VPWR sky130_fd_sc_hd__decap_4
XFILLER_0_46_29 VGND VGND VPWR VPWR sky130_fd_sc_hd__decap_4
XFILLER_0_55_223 VGND VGND VPWR VPWR sky130_fd_sc_hd__fill_1
XFILLER_0_11_54 VGND VGND VPWR VPWR sky130_fd_sc_hd__fill_2
XFILLER_0_11_65 VGND VGND VPWR VPWR sky130_fd_sc_hd__fill_1
XFILLER_0_11_87 VPWR VGND VPWR VGND sky130_ef_sc_hd__decap_12
X_1265_ net105 _0895_ _0897_ VGND VGND VPWR VPWR _0035_ sky130_fd_sc_hd__o21a_1
X_1403_ uart_rx_raspi_inst.bit_cnt\[1\] uart_rx_raspi_inst.bit_cnt\[0\] VGND VGND
+ VPWR VPWR _1003_ sky130_fd_sc_hd__or2_1
X_1334_ _0949_ net157 _0945_ VGND VGND VPWR VPWR _0950_ sky130_fd_sc_hd__mux2_1
Xinput3 rxd_raspi VGND VGND VPWR VPWR net3 sky130_fd_sc_hd__buf_1
X_1196_ _0852_ VGND VGND VPWR VPWR _0853_ sky130_fd_sc_hd__clkbuf_2
XFILLER_0_52_61 VPWR VGND VPWR VGND sky130_ef_sc_hd__decap_12
XFILLER_0_6_353 VGND VGND VPWR VPWR sky130_fd_sc_hd__fill_1
XFILLER_0_14_197 VGND VGND VPWR VPWR sky130_fd_sc_hd__decap_6
XFILLER_0_37_223 VGND VGND VPWR VPWR sky130_fd_sc_hd__fill_1
XFILLER_0_60_281 VPWR VGND VPWR VGND sky130_ef_sc_hd__decap_12
X_1050_ _0748_ _0749_ _0750_ dual_watchdog_inst.watchdog_fc.rising_edge_timeout.assert_time\[26\]
+ VGND VGND VPWR VPWR _0752_ sky130_fd_sc_hd__a31o_1
XFILLER_0_43_215 VGND VGND VPWR VPWR sky130_fd_sc_hd__decap_4
XFILLER_0_28_201 VPWR VGND VPWR VGND sky130_ef_sc_hd__decap_12
X_1952_ net153 VGND VGND VPWR VPWR _0664_ sky130_fd_sc_hd__inv_2
X_1883_ _0633_ _0634_ _1002_ VGND VGND VPWR VPWR _0287_ sky130_fd_sc_hd__a21oi_1
X_1248_ net44 _0884_ VGND VGND VPWR VPWR _0056_ sky130_fd_sc_hd__xnor2_1
XFILLER_0_47_83 VGND VGND VPWR VPWR sky130_fd_sc_hd__decap_6
XFILLER_0_47_61 VGND VGND VPWR VPWR sky130_fd_sc_hd__fill_1
X_1317_ uart_tx_raspi_inst.prescale_reg\[10\] uart_tx_raspi_inst.prescale_reg\[9\]
+ VGND VGND VPWR VPWR _0935_ sky130_fd_sc_hd__or2_1
XFILLER_0_2_41 VPWR VGND VPWR VGND sky130_ef_sc_hd__decap_12
X_2297_ clknet_leaf_23_clk _0321_ VGND VGND VPWR VPWR uart_rx_jetson_inst.data_reg\[5\]
+ sky130_fd_sc_hd__dfxtp_1
XPHY_118 VGND VGND VPWR VPWR sky130_fd_sc_hd__decap_3
XPHY_107 VGND VGND VPWR VPWR sky130_fd_sc_hd__decap_3
X_1179_ net196 _0839_ _0840_ _0841_ VGND VGND VPWR VPWR _0005_ sky130_fd_sc_hd__o211a_1
XFILLER_0_2_85 VPWR VGND VPWR VGND sky130_ef_sc_hd__decap_12
XFILLER_0_19_223 VGND VGND VPWR VPWR sky130_fd_sc_hd__fill_1
XFILLER_0_34_259 VGND VGND VPWR VPWR sky130_fd_sc_hd__fill_2
XFILLER_0_19_289 VGND VGND VPWR VPWR sky130_fd_sc_hd__fill_2
XPHY_9 VGND VGND VPWR VPWR sky130_fd_sc_hd__decap_3
XFILLER_0_57_329 VGND VGND VPWR VPWR sky130_fd_sc_hd__decap_6
XFILLER_0_33_281 VGND VGND VPWR VPWR sky130_fd_sc_hd__decap_6
XFILLER_0_0_337 VPWR VGND VPWR VGND sky130_ef_sc_hd__decap_12
X_2082_ clknet_leaf_12_clk _0162_ VGND VGND VPWR VPWR uart_tx_jetson_inst.prescale_reg\[5\]
+ sky130_fd_sc_hd__dfxtp_1
X_1102_ dual_watchdog_inst.watchdog_fc.rising_edge_timeout.assert_time\[6\] _0740_
+ _0741_ VGND VGND VPWR VPWR _0785_ sky130_fd_sc_hd__and3_1
X_2151_ clknet_leaf_30_clk _0231_ _0061_ VGND VGND VPWR VPWR dual_watchdog_inst.watchdog_fc.rising_edge_timeout.assert_time\[4\]
+ sky130_fd_sc_hd__dfrtp_1
X_2220_ clknet_leaf_26_clk _0005_ net11 VGND VGND VPWR VPWR dual_watchdog_inst.watchdog_fc.falling_edge_timeout.internal_count\[11\]
+ sky130_fd_sc_hd__dfrtp_1
XFILLER_0_17_42 VPWR VGND VPWR VGND sky130_ef_sc_hd__decap_12
XFILLER_0_48_307 VGND VGND VPWR VPWR sky130_fd_sc_hd__fill_1
X_1033_ dual_watchdog_inst.watchdog_fc.rising_edge_timeout.internal_count\[3\] dual_watchdog_inst.watchdog_fc.rising_edge_timeout.internal_count\[2\]
+ dual_watchdog_inst.watchdog_fc.rising_edge_timeout.internal_count\[5\] dual_watchdog_inst.watchdog_fc.rising_edge_timeout.internal_count\[4\]
+ VGND VGND VPWR VPWR _0736_ sky130_fd_sc_hd__or4_1
XFILLER_0_17_75 VGND VGND VPWR VPWR sky130_fd_sc_hd__decap_8
X_1797_ _0576_ VGND VGND VPWR VPWR _0259_ sky130_fd_sc_hd__clkbuf_1
X_1866_ _0938_ _0623_ _0609_ VGND VGND VPWR VPWR _0281_ sky130_fd_sc_hd__a21oi_1
XFILLER_0_33_96 VGND VGND VPWR VPWR sky130_fd_sc_hd__fill_2
X_1935_ net111 _0650_ _0652_ _0841_ VGND VGND VPWR VPWR _0294_ sky130_fd_sc_hd__o211a_1
XFILLER_0_58_93 VGND VGND VPWR VPWR sky130_fd_sc_hd__fill_1
XFILLER_0_30_251 VGND VGND VPWR VPWR sky130_fd_sc_hd__fill_1
XFILLER_0_22_207 VGND VGND VPWR VPWR sky130_fd_sc_hd__fill_1
XFILLER_0_54_29 VGND VGND VPWR VPWR sky130_fd_sc_hd__decap_4
XFILLER_0_53_332 VGND VGND VPWR VPWR sky130_fd_sc_hd__decap_4
X_1720_ uart_rx_jetson_inst.prescale_reg\[9\] _0540_ VGND VGND VPWR VPWR _0542_ sky130_fd_sc_hd__xor2_1
Xhold108 uart_rx_jetson_inst.prescale_reg\[12\] VGND VGND VPWR VPWR net122 sky130_fd_sc_hd__dlygate4sd3_1
X_1651_ _0489_ VGND VGND VPWR VPWR _0200_ sky130_fd_sc_hd__clkbuf_1
XTAP_457 VGND VPWR sky130_fd_sc_hd__tapvpwrvgnd_1
XTAP_446 VGND VPWR sky130_fd_sc_hd__tapvpwrvgnd_1
XTAP_435 VGND VPWR sky130_fd_sc_hd__tapvpwrvgnd_1
XTAP_424 VGND VPWR sky130_fd_sc_hd__tapvpwrvgnd_1
XTAP_413 VGND VPWR sky130_fd_sc_hd__tapvpwrvgnd_1
XTAP_402 VGND VPWR sky130_fd_sc_hd__tapvpwrvgnd_1
X_1582_ _0441_ _0440_ _0442_ VGND VGND VPWR VPWR _0178_ sky130_fd_sc_hd__a21oi_1
Xhold119 dual_watchdog_inst.watchdog_fc.falling_edge_timeout.internal_count\[10\]
+ VGND VGND VPWR VPWR net133 sky130_fd_sc_hd__dlygate4sd3_1
XTAP_479 VGND VPWR sky130_fd_sc_hd__tapvpwrvgnd_1
XTAP_468 VGND VPWR sky130_fd_sc_hd__tapvpwrvgnd_1
XFILLER_0_44_51 VGND VGND VPWR VPWR sky130_fd_sc_hd__fill_1
X_2203_ clknet_leaf_16_clk _0283_ VGND VGND VPWR VPWR uart_tx_raspi_inst.prescale_reg\[17\]
+ sky130_fd_sc_hd__dfxtp_1
X_2065_ clknet_leaf_0_clk _0145_ VGND VGND VPWR VPWR uart_rx_raspi_inst.prescale_reg\[12\]
+ sky130_fd_sc_hd__dfxtp_1
X_2134_ clknet_leaf_20_clk net29 VGND VGND VPWR VPWR uart_rx_jetson_inst.prescale_reg\[6\]
+ sky130_fd_sc_hd__dfxtp_1
XFILLER_0_60_72 VGND VGND VPWR VPWR sky130_fd_sc_hd__decap_6
XFILLER_0_48_137 VGND VGND VPWR VPWR sky130_fd_sc_hd__decap_3
X_1016_ dual_watchdog_inst.watchdog_fc.rising_edge_timeout.assert_time\[8\] dual_watchdog_inst.watchdog_fc.rising_edge_timeout.assert_time\[7\]
+ dual_watchdog_inst.watchdog_fc.rising_edge_timeout.assert_time\[6\] dual_watchdog_inst.watchdog_fc.rising_edge_timeout.assert_time\[5\]
+ VGND VGND VPWR VPWR _0719_ sky130_fd_sc_hd__or4_1
XFILLER_0_8_245 VGND VGND VPWR VPWR sky130_fd_sc_hd__decap_6
X_1849_ net214 _0610_ VGND VGND VPWR VPWR _0613_ sky130_fd_sc_hd__and2_1
X_1918_ dual_watchdog_inst.watchdog_fc.falling_edge_timeout.assert_time\[1\] dual_watchdog_inst.watchdog_fc.falling_edge_timeout.assert_time\[0\]
+ VGND VGND VPWR VPWR _0640_ sky130_fd_sc_hd__xor2_1
Xclkbuf_leaf_20_clk clknet_2_2__leaf_clk VGND VGND VPWR VPWR clknet_leaf_20_clk sky130_fd_sc_hd__clkbuf_16
XFILLER_0_14_65 VGND VGND VPWR VPWR sky130_fd_sc_hd__fill_1
Xclkbuf_leaf_11_clk clknet_2_3__leaf_clk VGND VGND VPWR VPWR clknet_leaf_11_clk sky130_fd_sc_hd__clkbuf_16
XFILLER_0_30_97 VGND VGND VPWR VPWR sky130_fd_sc_hd__fill_1
XFILLER_0_30_42 VPWR VGND VPWR VGND sky130_ef_sc_hd__decap_12
X_1703_ _0504_ _0529_ _0499_ VGND VGND VPWR VPWR _0530_ sky130_fd_sc_hd__o21a_1
X_1634_ uart_rx_jetson_inst.bit_cnt\[1\] uart_rx_jetson_inst.bit_cnt\[0\] VGND VGND
+ VPWR VPWR _0477_ sky130_fd_sc_hd__or2_1
X_1565_ uart_tx_jetson_inst.prescale_reg\[16\] _0372_ _0425_ VGND VGND VPWR VPWR _0431_
+ sky130_fd_sc_hd__or3_1
X_1496_ _0370_ net5 _0380_ VGND VGND VPWR VPWR _0381_ sky130_fd_sc_hd__mux2_1
XFILLER_0_39_84 VGND VGND VPWR VPWR sky130_fd_sc_hd__decap_6
XFILLER_0_39_51 VGND VGND VPWR VPWR sky130_fd_sc_hd__fill_1
XTAP_298 VGND VPWR sky130_fd_sc_hd__tapvpwrvgnd_1
XTAP_287 VGND VPWR sky130_fd_sc_hd__tapvpwrvgnd_1
XTAP_210 VGND VPWR sky130_fd_sc_hd__tapvpwrvgnd_1
XTAP_221 VGND VPWR sky130_fd_sc_hd__tapvpwrvgnd_1
XTAP_232 VGND VPWR sky130_fd_sc_hd__tapvpwrvgnd_1
XTAP_243 VGND VPWR sky130_fd_sc_hd__tapvpwrvgnd_1
XTAP_254 VGND VPWR sky130_fd_sc_hd__tapvpwrvgnd_1
XTAP_265 VGND VPWR sky130_fd_sc_hd__tapvpwrvgnd_1
XTAP_276 VGND VPWR sky130_fd_sc_hd__tapvpwrvgnd_1
X_2048_ clknet_leaf_10_clk _0128_ VGND VGND VPWR VPWR uart_rx_raspi_inst.m_axis_tdata_reg\[7\]
+ sky130_fd_sc_hd__dfxtp_1
X_2117_ clknet_leaf_16_clk _0197_ VGND VGND VPWR VPWR uart_rx_jetson_inst.m_axis_tdata_reg\[1\]
+ sky130_fd_sc_hd__dfxtp_1
XFILLER_0_44_173 VGND VGND VPWR VPWR sky130_fd_sc_hd__fill_2
Xfanout14 net1 VGND VGND VPWR VPWR net14 sky130_fd_sc_hd__clkbuf_2
XFILLER_0_44_195 VGND VGND VPWR VPWR sky130_fd_sc_hd__fill_1
XFILLER_0_32_357 VGND VGND VPWR VPWR sky130_fd_sc_hd__decap_4
X_1281_ _0907_ _0908_ VGND VGND VPWR VPWR _0040_ sky130_fd_sc_hd__nor2_1
X_1350_ _0960_ VGND VGND VPWR VPWR _0119_ sky130_fd_sc_hd__clkbuf_1
XFILLER_0_25_97 VGND VGND VPWR VPWR sky130_fd_sc_hd__decap_8
Xclkbuf_leaf_0_clk clknet_2_0__leaf_clk VGND VGND VPWR VPWR clknet_leaf_0_clk sky130_fd_sc_hd__clkbuf_16
X_1617_ _0463_ VGND VGND VPWR VPWR _0192_ sky130_fd_sc_hd__clkbuf_1
XFILLER_0_41_198 VGND VGND VPWR VPWR sky130_fd_sc_hd__decap_3
XFILLER_0_41_110 VGND VGND VPWR VPWR sky130_fd_sc_hd__fill_2
XFILLER_0_14_324 VGND VGND VPWR VPWR sky130_fd_sc_hd__fill_1
X_1548_ _0392_ _0417_ uart_tx_jetson_inst.prescale_reg\[10\] VGND VGND VPWR VPWR _0420_
+ sky130_fd_sc_hd__or3b_1
X_1479_ _0366_ VGND VGND VPWR VPWR _0151_ sky130_fd_sc_hd__clkbuf_1
XFILLER_0_9_340 VGND VGND VPWR VPWR sky130_fd_sc_hd__decap_4
XFILLER_0_32_132 VGND VGND VPWR VPWR sky130_fd_sc_hd__decap_4
XFILLER_0_1_3 VPWR VGND VPWR VGND sky130_ef_sc_hd__decap_12
XFILLER_0_55_279 VGND VGND VPWR VPWR sky130_fd_sc_hd__fill_1
X_1402_ _0995_ _0999_ _1000_ _1001_ _1002_ VGND VGND VPWR VPWR _0129_ sky130_fd_sc_hd__a221oi_1
XFILLER_0_11_99 VGND VGND VPWR VPWR sky130_fd_sc_hd__decap_4
X_1264_ _0764_ _0896_ VGND VGND VPWR VPWR _0897_ sky130_fd_sc_hd__nor2_1
X_1333_ uart_rx_jetson_inst.m_axis_tdata_reg\[2\] uart_tx_raspi_inst.data_reg\[3\]
+ _0930_ VGND VGND VPWR VPWR _0949_ sky130_fd_sc_hd__mux2_1
XFILLER_0_52_73 VGND VGND VPWR VPWR sky130_fd_sc_hd__decap_8
XFILLER_0_46_213 VGND VGND VPWR VPWR sky130_fd_sc_hd__decap_3
XFILLER_0_36_85 VGND VGND VPWR VPWR sky130_fd_sc_hd__decap_3
Xclkbuf_2_1__f_clk clknet_0_clk VGND VGND VPWR VPWR clknet_2_1__leaf_clk sky130_fd_sc_hd__clkbuf_16
X_1195_ dual_watchdog_inst.watchdog_fc.falling_edge_timeout.internal_count\[15\] dual_watchdog_inst.watchdog_fc.falling_edge_timeout.internal_count\[14\]
+ _0804_ _0846_ VGND VGND VPWR VPWR _0852_ sky130_fd_sc_hd__and4_1
XFILLER_0_46_268 VGND VGND VPWR VPWR sky130_fd_sc_hd__fill_2
XFILLER_0_37_257 VGND VGND VPWR VPWR sky130_fd_sc_hd__decap_6
XFILLER_0_60_293 VPWR VGND VPWR VGND sky130_ef_sc_hd__decap_12
XFILLER_0_57_18 VPWR VGND VPWR VGND sky130_ef_sc_hd__decap_12
XFILLER_0_28_213 VGND VGND VPWR VPWR sky130_fd_sc_hd__decap_6
X_1951_ net160 _0662_ _0663_ _0841_ VGND VGND VPWR VPWR _0299_ sky130_fd_sc_hd__o211a_1
XFILLER_0_3_335 VGND VGND VPWR VPWR sky130_fd_sc_hd__fill_1
X_1882_ uart_tx_raspi_inst.bit_cnt\[2\] _0632_ VGND VGND VPWR VPWR _0634_ sky130_fd_sc_hd__or2_1
XFILLER_0_11_157 VGND VGND VPWR VPWR sky130_fd_sc_hd__decap_4
X_1247_ _0885_ VGND VGND VPWR VPWR _0055_ sky130_fd_sc_hd__clkbuf_1
X_1316_ uart_tx_raspi_inst.prescale_reg\[7\] uart_tx_raspi_inst.prescale_reg\[6\]
+ uart_tx_raspi_inst.prescale_reg\[5\] uart_tx_raspi_inst.prescale_reg\[4\] VGND VGND
+ VPWR VPWR _0934_ sky130_fd_sc_hd__or4_4
XFILLER_0_2_53 VPWR VGND VPWR VGND sky130_ef_sc_hd__decap_12
X_1178_ _0808_ VGND VGND VPWR VPWR _0841_ sky130_fd_sc_hd__clkbuf_4
X_2296_ clknet_leaf_24_clk _0320_ VGND VGND VPWR VPWR uart_rx_jetson_inst.data_reg\[4\]
+ sky130_fd_sc_hd__dfxtp_1
XPHY_119 VGND VGND VPWR VPWR sky130_fd_sc_hd__decap_3
XPHY_108 VGND VGND VPWR VPWR sky130_fd_sc_hd__decap_3
XFILLER_0_2_97 VPWR VGND VPWR VGND sky130_ef_sc_hd__decap_12
XFILLER_0_19_202 VGND VGND VPWR VPWR sky130_fd_sc_hd__decap_4
XFILLER_0_18_290 VGND VGND VPWR VPWR sky130_fd_sc_hd__decap_8
XFILLER_0_0_305 VGND VGND VPWR VPWR sky130_fd_sc_hd__decap_3
XFILLER_0_0_349 VPWR VGND VPWR VGND sky130_ef_sc_hd__decap_12
X_1032_ dual_watchdog_inst.watchdog_fc.rising_edge_timeout.internal_count\[7\] dual_watchdog_inst.watchdog_fc.rising_edge_timeout.internal_count\[9\]
+ dual_watchdog_inst.watchdog_fc.rising_edge_timeout.internal_count\[8\] dual_watchdog_inst.watchdog_fc.rising_edge_timeout.internal_count\[6\]
+ VGND VGND VPWR VPWR _0735_ sky130_fd_sc_hd__or4bb_1
X_2081_ clknet_leaf_14_clk _0161_ VGND VGND VPWR VPWR uart_tx_jetson_inst.prescale_reg\[4\]
+ sky130_fd_sc_hd__dfxtp_1
X_2150_ clknet_leaf_2_clk _0230_ _0060_ VGND VGND VPWR VPWR dual_watchdog_inst.watchdog_fc.rising_edge_timeout.assert_time\[3\]
+ sky130_fd_sc_hd__dfrtp_1
X_1101_ net166 _0742_ _0784_ VGND VGND VPWR VPWR _0235_ sky130_fd_sc_hd__o21a_1
XFILLER_0_17_54 VGND VGND VPWR VPWR sky130_fd_sc_hd__fill_2
X_1934_ _0645_ _0651_ VGND VGND VPWR VPWR _0652_ sky130_fd_sc_hd__nand2_1
X_1796_ _0575_ net132 _0571_ VGND VGND VPWR VPWR _0576_ sky130_fd_sc_hd__mux2_1
X_1865_ net26 _0621_ VGND VGND VPWR VPWR _0623_ sky130_fd_sc_hd__nand2_1
XFILLER_0_31_219 VGND VGND VPWR VPWR sky130_fd_sc_hd__decap_4
XFILLER_0_16_238 VGND VGND VPWR VPWR sky130_fd_sc_hd__fill_2
XFILLER_0_42_3 VPWR VGND VPWR VGND sky130_ef_sc_hd__decap_12
X_2279_ clknet_leaf_28_clk net135 net10 VGND VGND VPWR VPWR dual_watchdog_inst.watchdog_fc.falling_edge_timeout.assert_time\[15\]
+ sky130_fd_sc_hd__dfrtp_1
XFILLER_0_57_116 VPWR VGND VPWR VGND sky130_ef_sc_hd__decap_12
Xhold109 uart_tx_jetson_inst.prescale_reg\[7\] VGND VGND VPWR VPWR net123 sky130_fd_sc_hd__dlygate4sd3_1
X_1581_ uart_tx_jetson_inst.bit_cnt\[2\] _0439_ _1008_ VGND VGND VPWR VPWR _0442_
+ sky130_fd_sc_hd__a21o_1
X_1650_ _0986_ _0488_ VGND VGND VPWR VPWR _0489_ sky130_fd_sc_hd__and2b_1
XTAP_469 VGND VPWR sky130_fd_sc_hd__tapvpwrvgnd_1
XTAP_458 VGND VPWR sky130_fd_sc_hd__tapvpwrvgnd_1
XTAP_447 VGND VPWR sky130_fd_sc_hd__tapvpwrvgnd_1
XTAP_436 VGND VPWR sky130_fd_sc_hd__tapvpwrvgnd_1
XTAP_425 VGND VPWR sky130_fd_sc_hd__tapvpwrvgnd_1
XTAP_414 VGND VPWR sky130_fd_sc_hd__tapvpwrvgnd_1
XTAP_403 VGND VPWR sky130_fd_sc_hd__tapvpwrvgnd_1
X_2202_ clknet_leaf_14_clk net101 VGND VGND VPWR VPWR uart_tx_raspi_inst.prescale_reg\[16\]
+ sky130_fd_sc_hd__dfxtp_1
XFILLER_0_28_75 VGND VGND VPWR VPWR sky130_fd_sc_hd__decap_8
XFILLER_0_0_113 VPWR VGND VPWR VGND sky130_ef_sc_hd__decap_12
XFILLER_0_48_116 VPWR VGND VPWR VGND sky130_ef_sc_hd__decap_12
X_2064_ clknet_leaf_1_clk _0144_ VGND VGND VPWR VPWR uart_rx_raspi_inst.prescale_reg\[11\]
+ sky130_fd_sc_hd__dfxtp_1
X_1015_ dual_watchdog_inst.watchdog_fc.rising_edge_timeout.assert_time\[4\] dual_watchdog_inst.watchdog_fc.rising_edge_timeout.assert_time\[3\]
+ dual_watchdog_inst.watchdog_fc.rising_edge_timeout.assert_time\[1\] dual_watchdog_inst.watchdog_fc.rising_edge_timeout.assert_time\[2\]
+ VGND VGND VPWR VPWR _0718_ sky130_fd_sc_hd__or4b_1
X_2133_ clknet_leaf_21_clk _0213_ VGND VGND VPWR VPWR uart_rx_jetson_inst.prescale_reg\[5\]
+ sky130_fd_sc_hd__dfxtp_1
X_1917_ dual_watchdog_inst.watchdog_fc.falling_edge_timeout.assert_time\[0\] _0821_
+ _0002_ VGND VGND VPWR VPWR _0289_ sky130_fd_sc_hd__o21ai_1
X_1848_ net214 _0610_ VGND VGND VPWR VPWR _0612_ sky130_fd_sc_hd__nor2_1
XFILLER_0_8_63 VGND VGND VPWR VPWR sky130_fd_sc_hd__fill_1
X_1779_ _1009_ _0563_ VGND VGND VPWR VPWR _0254_ sky130_fd_sc_hd__nor2_1
XFILLER_0_39_138 VGND VGND VPWR VPWR sky130_fd_sc_hd__fill_1
XFILLER_0_38_193 VGND VGND VPWR VPWR sky130_fd_sc_hd__decap_3
XFILLER_0_38_160 VGND VGND VPWR VPWR sky130_fd_sc_hd__fill_1
XFILLER_0_53_185 VGND VGND VPWR VPWR sky130_fd_sc_hd__decap_4
X_1564_ _0414_ _0430_ VGND VGND VPWR VPWR _0172_ sky130_fd_sc_hd__nor2_1
XFILLER_0_30_54 VGND VGND VPWR VPWR sky130_fd_sc_hd__decap_8
X_1702_ uart_rx_jetson_inst.prescale_reg\[4\] _0469_ VGND VGND VPWR VPWR _0529_ sky130_fd_sc_hd__xor2_1
XFILLER_0_5_249 VGND VGND VPWR VPWR sky130_fd_sc_hd__fill_1
X_1633_ uart_rx_jetson_inst.bit_cnt\[3\] uart_rx_jetson_inst.bit_cnt\[2\] uart_rx_jetson_inst.bit_cnt\[1\]
+ VGND VGND VPWR VPWR _0476_ sky130_fd_sc_hd__nor3_2
X_1495_ uart_rx_raspi_inst.m_axis_tvalid_reg _0371_ _0379_ VGND VGND VPWR VPWR _0380_
+ sky130_fd_sc_hd__o21ai_1
XTAP_299 VGND VPWR sky130_fd_sc_hd__tapvpwrvgnd_1
XTAP_288 VGND VPWR sky130_fd_sc_hd__tapvpwrvgnd_1
XTAP_200 VGND VPWR sky130_fd_sc_hd__tapvpwrvgnd_1
XTAP_211 VGND VPWR sky130_fd_sc_hd__tapvpwrvgnd_1
XTAP_222 VGND VPWR sky130_fd_sc_hd__tapvpwrvgnd_1
XTAP_233 VGND VPWR sky130_fd_sc_hd__tapvpwrvgnd_1
XTAP_244 VGND VPWR sky130_fd_sc_hd__tapvpwrvgnd_1
XTAP_255 VGND VPWR sky130_fd_sc_hd__tapvpwrvgnd_1
XTAP_266 VGND VPWR sky130_fd_sc_hd__tapvpwrvgnd_1
XTAP_277 VGND VPWR sky130_fd_sc_hd__tapvpwrvgnd_1
X_2047_ clknet_leaf_10_clk _0127_ VGND VGND VPWR VPWR uart_rx_raspi_inst.m_axis_tdata_reg\[6\]
+ sky130_fd_sc_hd__dfxtp_1
X_2116_ clknet_leaf_16_clk _0196_ VGND VGND VPWR VPWR uart_rx_jetson_inst.m_axis_tdata_reg\[0\]
+ sky130_fd_sc_hd__dfxtp_1
XFILLER_0_44_141 VPWR VGND VPWR VGND sky130_ef_sc_hd__decap_12
XFILLER_0_17_311 VGND VGND VPWR VPWR sky130_fd_sc_hd__decap_4
XFILLER_0_35_141 VGND VGND VPWR VPWR sky130_fd_sc_hd__decap_8
XFILLER_0_50_111 VGND VGND VPWR VPWR sky130_fd_sc_hd__fill_1
XFILLER_0_23_314 VGND VGND VPWR VPWR sky130_fd_sc_hd__fill_1
XFILLER_0_23_358 VGND VGND VPWR VPWR sky130_fd_sc_hd__decap_4
X_1280_ dual_watchdog_inst.watchdog_fc.rising_edge_timeout.internal_count\[19\] dual_watchdog_inst.watchdog_fc.rising_edge_timeout.internal_count\[18\]
+ _0733_ _0900_ VGND VGND VPWR VPWR _0908_ sky130_fd_sc_hd__and4_1
XFILLER_0_25_54 VGND VGND VPWR VPWR sky130_fd_sc_hd__fill_2
XFILLER_0_41_86 VGND VGND VPWR VPWR sky130_fd_sc_hd__fill_1
XFILLER_0_41_53 VGND VGND VPWR VPWR sky130_fd_sc_hd__decap_3
XFILLER_0_26_163 VGND VGND VPWR VPWR sky130_fd_sc_hd__decap_3
X_1616_ _0462_ net185 _0454_ VGND VGND VPWR VPWR _0463_ sky130_fd_sc_hd__mux2_1
X_1547_ _0417_ _0392_ uart_tx_jetson_inst.prescale_reg\[10\] VGND VGND VPWR VPWR _0419_
+ sky130_fd_sc_hd__o21bai_1
XFILLER_0_41_166 VGND VGND VPWR VPWR sky130_fd_sc_hd__fill_2
XFILLER_0_1_241 VPWR VGND VPWR VGND sky130_ef_sc_hd__decap_12
XFILLER_0_49_200 VPWR VGND VPWR VGND sky130_ef_sc_hd__decap_12
X_1478_ _1002_ _0970_ uart_rx_raspi_inst.prescale_reg\[18\] VGND VGND VPWR VPWR _0366_
+ sky130_fd_sc_hd__and3b_1
XFILLER_0_17_163 VGND VGND VPWR VPWR sky130_fd_sc_hd__fill_1
XFILLER_0_55_214 VGND VGND VPWR VPWR sky130_fd_sc_hd__fill_1
XFILLER_0_23_111 VGND VGND VPWR VPWR sky130_fd_sc_hd__fill_1
X_1401_ _0963_ VGND VGND VPWR VPWR _1002_ sky130_fd_sc_hd__clkbuf_4
X_1263_ dual_watchdog_inst.watchdog_fc.rising_edge_timeout.internal_count\[13\] dual_watchdog_inst.watchdog_fc.rising_edge_timeout.internal_count\[12\]
+ dual_watchdog_inst.watchdog_fc.rising_edge_timeout.internal_count\[14\] _0889_ VGND
+ VGND VPWR VPWR _0896_ sky130_fd_sc_hd__and4_1
XFILLER_0_36_75 VGND VGND VPWR VPWR sky130_fd_sc_hd__decap_8
X_1332_ _0948_ VGND VGND VPWR VPWR _0113_ sky130_fd_sc_hd__clkbuf_1
X_1194_ dual_watchdog_inst.watchdog_fc.falling_edge_timeout.internal_count\[16\] _0849_
+ net169 VGND VGND VPWR VPWR _0851_ sky130_fd_sc_hd__a21oi_1
XFILLER_0_52_85 VGND VGND VPWR VPWR sky130_fd_sc_hd__fill_2
XFILLER_0_6_300 VGND VGND VPWR VPWR sky130_fd_sc_hd__fill_1
XFILLER_0_14_111 VGND VGND VPWR VPWR sky130_fd_sc_hd__decap_4
XFILLER_0_14_155 VGND VGND VPWR VPWR sky130_fd_sc_hd__decap_3
XFILLER_0_14_188 VGND VGND VPWR VPWR sky130_fd_sc_hd__fill_1
XFILLER_0_37_225 VPWR VGND VPWR VGND sky130_ef_sc_hd__decap_12
XFILLER_0_9_193 VGND VGND VPWR VPWR sky130_fd_sc_hd__decap_6
XFILLER_0_7_108 VGND VGND VPWR VPWR sky130_fd_sc_hd__decap_4
X_1950_ dual_watchdog_inst.watchdog_fc.falling_edge_timeout.assert_time\[10\] _0662_
+ VGND VGND VPWR VPWR _0663_ sky130_fd_sc_hd__nand2_1
XFILLER_0_51_250 VGND VGND VPWR VPWR sky130_fd_sc_hd__decap_6
XFILLER_0_36_280 VGND VGND VPWR VPWR sky130_fd_sc_hd__decap_4
X_1881_ net113 _0631_ VGND VGND VPWR VPWR _0633_ sky130_fd_sc_hd__nand2_1
XFILLER_0_44_7 VGND VGND VPWR VPWR sky130_fd_sc_hd__fill_1
X_1315_ _0932_ VGND VGND VPWR VPWR _0933_ sky130_fd_sc_hd__buf_6
XFILLER_0_11_169 VGND VGND VPWR VPWR sky130_fd_sc_hd__decap_6
X_1246_ _0738_ _0883_ _0884_ VGND VGND VPWR VPWR _0885_ sky130_fd_sc_hd__and3_1
X_1177_ dual_watchdog_inst.watchdog_fc.falling_edge_timeout.internal_count\[11\] _0839_
+ VGND VGND VPWR VPWR _0840_ sky130_fd_sc_hd__nand2_1
XFILLER_0_2_65 VPWR VGND VPWR VGND sky130_ef_sc_hd__decap_12
X_2295_ clknet_leaf_24_clk _0319_ VGND VGND VPWR VPWR uart_rx_jetson_inst.data_reg\[3\]
+ sky130_fd_sc_hd__dfxtp_1
XFILLER_0_59_361 VGND VGND VPWR VPWR sky130_fd_sc_hd__fill_1
XPHY_109 VGND VGND VPWR VPWR sky130_fd_sc_hd__decap_3
XFILLER_0_25_206 VGND VGND VPWR VPWR sky130_fd_sc_hd__decap_3
X_1031_ dual_watchdog_inst.watchdog_fc.rising_edge_timeout.internal_count\[1\] _0732_
+ dual_watchdog_inst.watchdog_fc.rising_edge_timeout.internal_count\[0\] _0733_ VGND
+ VGND VPWR VPWR _0734_ sky130_fd_sc_hd__or4b_1
XFILLER_0_48_309 VGND VGND VPWR VPWR sky130_fd_sc_hd__decap_4
X_2080_ clknet_leaf_14_clk _0160_ VGND VGND VPWR VPWR uart_tx_jetson_inst.prescale_reg\[3\]
+ sky130_fd_sc_hd__dfxtp_1
X_1100_ _0764_ _0782_ VGND VGND VPWR VPWR _0784_ sky130_fd_sc_hd__nor2_1
X_1933_ dual_watchdog_inst.watchdog_fc.falling_edge_timeout.assert_time\[5\] dual_watchdog_inst.watchdog_fc.falling_edge_timeout.assert_time\[4\]
+ VGND VGND VPWR VPWR _0651_ sky130_fd_sc_hd__and2_1
XFILLER_0_16_206 VGND VGND VPWR VPWR sky130_fd_sc_hd__decap_4
X_1795_ uart_rx_raspi_inst.m_axis_tdata_reg\[2\] uart_tx_jetson_inst.data_reg\[3\]
+ _0383_ VGND VGND VPWR VPWR _0575_ sky130_fd_sc_hd__mux2_1
X_1864_ _0621_ _0622_ _0609_ VGND VGND VPWR VPWR _0280_ sky130_fd_sc_hd__a21oi_1
XFILLER_0_3_177 VPWR VGND VPWR VGND sky130_ef_sc_hd__decap_12
XFILLER_0_3_111 VGND VGND VPWR VPWR sky130_fd_sc_hd__fill_1
XFILLER_0_24_250 VGND VGND VPWR VPWR sky130_fd_sc_hd__fill_2
XFILLER_0_24_294 VPWR VGND VPWR VGND sky130_ef_sc_hd__decap_12
XFILLER_0_58_73 VGND VGND VPWR VPWR sky130_fd_sc_hd__decap_4
XFILLER_0_35_3 VPWR VGND VPWR VGND sky130_ef_sc_hd__decap_12
X_2278_ clknet_leaf_27_clk _0303_ net10 VGND VGND VPWR VPWR dual_watchdog_inst.watchdog_fc.falling_edge_timeout.assert_time\[14\]
+ sky130_fd_sc_hd__dfrtp_1
X_1229_ _0872_ net110 VGND VGND VPWR VPWR _0049_ sky130_fd_sc_hd__nor2_1
XFILLER_0_47_353 VGND VGND VPWR VPWR sky130_fd_sc_hd__decap_8
XFILLER_0_15_261 VGND VGND VPWR VPWR sky130_fd_sc_hd__fill_1
XFILLER_0_30_264 VPWR VGND VPWR VGND sky130_ef_sc_hd__decap_12
XFILLER_0_30_253 VGND VGND VPWR VPWR sky130_fd_sc_hd__fill_2
XFILLER_0_57_128 VPWR VGND VPWR VGND sky130_ef_sc_hd__decap_12
XFILLER_0_53_323 VGND VGND VPWR VPWR sky130_fd_sc_hd__decap_6
X_1580_ net73 VGND VGND VPWR VPWR _0441_ sky130_fd_sc_hd__inv_2
XFILLER_0_0_125 VPWR VGND VPWR VGND sky130_ef_sc_hd__decap_12
XTAP_459 VGND VPWR sky130_fd_sc_hd__tapvpwrvgnd_1
XTAP_448 VGND VPWR sky130_fd_sc_hd__tapvpwrvgnd_1
XTAP_437 VGND VPWR sky130_fd_sc_hd__tapvpwrvgnd_1
XTAP_426 VGND VPWR sky130_fd_sc_hd__tapvpwrvgnd_1
XTAP_415 VGND VPWR sky130_fd_sc_hd__tapvpwrvgnd_1
XTAP_404 VGND VPWR sky130_fd_sc_hd__tapvpwrvgnd_1
X_2201_ clknet_leaf_14_clk net27 VGND VGND VPWR VPWR uart_tx_raspi_inst.prescale_reg\[15\]
+ sky130_fd_sc_hd__dfxtp_1
XFILLER_0_28_21 VGND VGND VPWR VPWR sky130_fd_sc_hd__fill_1
X_2132_ clknet_leaf_21_clk _0212_ VGND VGND VPWR VPWR uart_rx_jetson_inst.prescale_reg\[4\]
+ sky130_fd_sc_hd__dfxtp_1
XFILLER_0_0_169 VPWR VGND VPWR VGND sky130_ef_sc_hd__decap_12
XFILLER_0_48_128 VGND VGND VPWR VPWR sky130_fd_sc_hd__decap_6
XFILLER_0_44_75 VGND VGND VPWR VPWR sky130_fd_sc_hd__fill_1
XFILLER_0_44_42 VGND VGND VPWR VPWR sky130_fd_sc_hd__fill_1
X_2063_ clknet_leaf_1_clk _0143_ VGND VGND VPWR VPWR uart_rx_raspi_inst.prescale_reg\[10\]
+ sky130_fd_sc_hd__dfxtp_1
XFILLER_0_60_85 VPWR VGND VPWR VGND sky130_ef_sc_hd__decap_12
XFILLER_0_60_41 VPWR VGND VPWR VGND sky130_ef_sc_hd__decap_12
X_1916_ _0558_ VGND VGND VPWR VPWR _0110_ sky130_fd_sc_hd__inv_2
X_1847_ _0610_ _0611_ _0609_ VGND VGND VPWR VPWR _0274_ sky130_fd_sc_hd__a21oi_1
XFILLER_0_29_353 VGND VGND VPWR VPWR sky130_fd_sc_hd__fill_1
XFILLER_0_8_97 VGND VGND VPWR VPWR sky130_fd_sc_hd__fill_1
X_1778_ _0562_ net86 _0479_ VGND VGND VPWR VPWR _0563_ sky130_fd_sc_hd__a21oi_1
XFILLER_0_35_301 VGND VGND VPWR VPWR sky130_fd_sc_hd__decap_3
XFILLER_0_14_12 VGND VGND VPWR VPWR sky130_fd_sc_hd__decap_6
X_1701_ _0499_ _0528_ _0520_ VGND VGND VPWR VPWR _0211_ sky130_fd_sc_hd__a21oi_1
X_1563_ net70 _0429_ VGND VGND VPWR VPWR _0430_ sky130_fd_sc_hd__xnor2_1
X_1494_ _0378_ VGND VGND VPWR VPWR _0379_ sky130_fd_sc_hd__clkbuf_4
XTAP_201 VGND VPWR sky130_fd_sc_hd__tapvpwrvgnd_1
XTAP_212 VGND VPWR sky130_fd_sc_hd__tapvpwrvgnd_1
XTAP_223 VGND VPWR sky130_fd_sc_hd__tapvpwrvgnd_1
X_1632_ uart_rx_jetson_inst.prescale_reg\[18\] _0474_ VGND VGND VPWR VPWR _0475_ sky130_fd_sc_hd__nor2_1
X_2115_ clknet_leaf_7_clk _0195_ VGND VGND VPWR VPWR uart_rx_raspi_inst.data_reg\[7\]
+ sky130_fd_sc_hd__dfxtp_1
XTAP_289 VGND VPWR sky130_fd_sc_hd__tapvpwrvgnd_1
XTAP_234 VGND VPWR sky130_fd_sc_hd__tapvpwrvgnd_1
XTAP_245 VGND VPWR sky130_fd_sc_hd__tapvpwrvgnd_1
XTAP_256 VGND VPWR sky130_fd_sc_hd__tapvpwrvgnd_1
XTAP_267 VGND VPWR sky130_fd_sc_hd__tapvpwrvgnd_1
XTAP_278 VGND VPWR sky130_fd_sc_hd__tapvpwrvgnd_1
X_2046_ clknet_leaf_10_clk _0126_ VGND VGND VPWR VPWR uart_rx_raspi_inst.m_axis_tdata_reg\[5\]
+ sky130_fd_sc_hd__dfxtp_1
XFILLER_0_29_150 VPWR VGND VPWR VGND sky130_ef_sc_hd__decap_12
XFILLER_0_44_153 VPWR VGND VPWR VGND sky130_ef_sc_hd__decap_12
XFILLER_0_2_209 VGND VGND VPWR VPWR sky130_fd_sc_hd__decap_4
XFILLER_0_23_337 VGND VGND VPWR VPWR sky130_fd_sc_hd__fill_1
XFILLER_0_58_212 VGND VGND VPWR VPWR sky130_fd_sc_hd__fill_1
XFILLER_0_41_65 VGND VGND VPWR VPWR sky130_fd_sc_hd__fill_1
XFILLER_0_26_197 VGND VGND VPWR VPWR sky130_fd_sc_hd__fill_2
XFILLER_0_26_153 VGND VGND VPWR VPWR sky130_fd_sc_hd__fill_2
X_1615_ uart_rx_raspi_inst.data_reg\[5\] _0974_ VGND VGND VPWR VPWR _0462_ sky130_fd_sc_hd__and2_1
X_1546_ _0417_ net76 _0414_ VGND VGND VPWR VPWR _0166_ sky130_fd_sc_hd__a21oi_1
X_1477_ _0970_ net65 _0345_ VGND VGND VPWR VPWR _0150_ sky130_fd_sc_hd__a21oi_1
XFILLER_0_5_87 VGND VGND VPWR VPWR sky130_fd_sc_hd__fill_1
XFILLER_0_5_54 VGND VGND VPWR VPWR sky130_fd_sc_hd__fill_2
XFILLER_0_1_220 VGND VGND VPWR VPWR sky130_fd_sc_hd__decap_4
XFILLER_0_1_253 VPWR VGND VPWR VGND sky130_ef_sc_hd__decap_12
XFILLER_0_49_212 VGND VGND VPWR VPWR sky130_fd_sc_hd__decap_4
XFILLER_0_49_256 VGND VGND VPWR VPWR sky130_fd_sc_hd__fill_2
XFILLER_0_49_234 VGND VGND VPWR VPWR sky130_fd_sc_hd__decap_4
X_2029_ uart_rx_jetson_inst.rxd_reg net232 _0703_ VGND VGND VPWR VPWR _0717_ sky130_fd_sc_hd__mux2_1
XFILLER_0_32_178 VGND VGND VPWR VPWR sky130_fd_sc_hd__fill_2
XFILLER_0_20_318 VGND VGND VPWR VPWR sky130_fd_sc_hd__decap_4
XFILLER_0_55_204 VGND VGND VPWR VPWR sky130_fd_sc_hd__fill_1
XFILLER_0_11_57 VGND VGND VPWR VPWR sky130_fd_sc_hd__decap_8
X_1400_ uart_rx_raspi_inst.prescale_reg\[18\] _0970_ VGND VGND VPWR VPWR _1001_ sky130_fd_sc_hd__nor2_4
X_1331_ _0947_ net176 net15 VGND VGND VPWR VPWR _0948_ sky130_fd_sc_hd__mux2_4
X_1262_ dual_watchdog_inst.watchdog_fc.rising_edge_timeout.internal_count\[13\] dual_watchdog_inst.watchdog_fc.rising_edge_timeout.internal_count\[12\]
+ _0882_ _0894_ VGND VGND VPWR VPWR _0895_ sky130_fd_sc_hd__and4_1
XFILLER_0_36_65 VGND VGND VPWR VPWR sky130_fd_sc_hd__decap_3
X_1193_ net204 _0849_ _0850_ _0841_ VGND VGND VPWR VPWR _0010_ sky130_fd_sc_hd__o211a_1
XFILLER_0_6_323 VGND VGND VPWR VPWR sky130_fd_sc_hd__fill_1
XFILLER_0_6_345 VGND VGND VPWR VPWR sky130_fd_sc_hd__decap_8
XFILLER_0_14_145 VGND VGND VPWR VPWR sky130_fd_sc_hd__decap_6
X_1529_ uart_tx_jetson_inst.prescale_reg\[4\] _0373_ uart_tx_jetson_inst.prescale_reg\[5\]
+ VGND VGND VPWR VPWR _0406_ sky130_fd_sc_hd__o21ai_1
XFILLER_0_45_281 VGND VGND VPWR VPWR sky130_fd_sc_hd__decap_3
XFILLER_0_37_237 VPWR VGND VPWR VGND sky130_ef_sc_hd__decap_12
XPHY_90 VGND VGND VPWR VPWR sky130_fd_sc_hd__decap_3
XFILLER_0_22_34 VGND VGND VPWR VPWR sky130_fd_sc_hd__decap_8
X_1880_ _0630_ _0632_ _1002_ VGND VGND VPWR VPWR _0286_ sky130_fd_sc_hd__a21oi_1
XFILLER_0_3_337 VPWR VGND VPWR VGND sky130_ef_sc_hd__decap_12
XFILLER_0_47_75 VGND VGND VPWR VPWR sky130_fd_sc_hd__fill_1
XFILLER_0_47_53 VGND VGND VPWR VPWR sky130_fd_sc_hd__decap_3
X_1314_ uart_tx_raspi_inst.prescale_reg\[3\] uart_tx_raspi_inst.prescale_reg\[2\]
+ uart_tx_raspi_inst.prescale_reg\[1\] uart_tx_raspi_inst.prescale_reg\[0\] VGND VGND
+ VPWR VPWR _0932_ sky130_fd_sc_hd__or4_4
X_2294_ clknet_leaf_24_clk _0318_ VGND VGND VPWR VPWR uart_rx_jetson_inst.data_reg\[2\]
+ sky130_fd_sc_hd__dfxtp_1
X_1245_ dual_watchdog_inst.watchdog_fc.rising_edge_timeout.internal_count\[8\] _0882_
+ VGND VGND VPWR VPWR _0884_ sky130_fd_sc_hd__nand2_1
X_1176_ _0838_ _0839_ VGND VGND VPWR VPWR _0004_ sky130_fd_sc_hd__nor2_1
XFILLER_0_2_77 VGND VGND VPWR VPWR sky130_fd_sc_hd__decap_6
XFILLER_0_27_292 VGND VGND VPWR VPWR sky130_fd_sc_hd__decap_6
XFILLER_0_42_273 VGND VGND VPWR VPWR sky130_fd_sc_hd__fill_1
XFILLER_0_42_251 VGND VGND VPWR VPWR sky130_fd_sc_hd__fill_1
XFILLER_0_10_181 VPWR VGND VPWR VGND sky130_ef_sc_hd__decap_12
XFILLER_0_33_295 VGND VGND VPWR VPWR sky130_fd_sc_hd__fill_2
XFILLER_0_17_12 VPWR VGND VPWR VGND sky130_ef_sc_hd__decap_12
X_1030_ dual_watchdog_inst.watchdog_fc.rising_edge_timeout.internal_count\[17\] dual_watchdog_inst.watchdog_fc.rising_edge_timeout.internal_count\[16\]
+ VGND VGND VPWR VPWR _0733_ sky130_fd_sc_hd__and2_1
XFILLER_0_56_321 VPWR VGND VPWR VGND sky130_ef_sc_hd__decap_12
X_1863_ net237 _0618_ net84 VGND VGND VPWR VPWR _0622_ sky130_fd_sc_hd__o21ai_1
XFILLER_0_33_55 VGND VGND VPWR VPWR sky130_fd_sc_hd__fill_1
X_1932_ _0821_ _0649_ _0650_ VGND VGND VPWR VPWR _0293_ sky130_fd_sc_hd__nor3_1
XFILLER_0_58_41 VPWR VGND VPWR VGND sky130_ef_sc_hd__decap_12
X_1794_ _0574_ VGND VGND VPWR VPWR _0258_ sky130_fd_sc_hd__clkbuf_1
XFILLER_0_3_189 VGND VGND VPWR VPWR sky130_fd_sc_hd__decap_4
X_1228_ net95 dual_watchdog_inst.watchdog_fc.rising_edge_timeout.internal_count\[0\]
+ net109 VGND VGND VPWR VPWR _0873_ sky130_fd_sc_hd__a21oi_1
XFILLER_0_28_3 VPWR VGND VPWR VGND sky130_ef_sc_hd__decap_12
X_2277_ clknet_leaf_26_clk _0302_ net10 VGND VGND VPWR VPWR dual_watchdog_inst.watchdog_fc.falling_edge_timeout.assert_time\[13\]
+ sky130_fd_sc_hd__dfrtp_1
X_1159_ dual_watchdog_inst.watchdog_fc.falling_edge_timeout.internal_count\[4\] _0825_
+ net53 VGND VGND VPWR VPWR _0828_ sky130_fd_sc_hd__a21oi_1
XFILLER_0_30_276 VGND VGND VPWR VPWR sky130_fd_sc_hd__decap_3
Xclkbuf_leaf_23_clk clknet_2_2__leaf_clk VGND VGND VPWR VPWR clknet_leaf_23_clk sky130_fd_sc_hd__clkbuf_16
XTAP_405 VGND VPWR sky130_fd_sc_hd__tapvpwrvgnd_1
XFILLER_0_0_137 VGND VGND VPWR VPWR sky130_fd_sc_hd__decap_3
XFILLER_0_21_221 VGND VGND VPWR VPWR sky130_fd_sc_hd__decap_3
XTAP_449 VGND VPWR sky130_fd_sc_hd__tapvpwrvgnd_1
XTAP_438 VGND VPWR sky130_fd_sc_hd__tapvpwrvgnd_1
XTAP_427 VGND VPWR sky130_fd_sc_hd__tapvpwrvgnd_1
XTAP_416 VGND VPWR sky130_fd_sc_hd__tapvpwrvgnd_1
X_2200_ clknet_leaf_14_clk net238 VGND VGND VPWR VPWR uart_tx_raspi_inst.prescale_reg\[14\]
+ sky130_fd_sc_hd__dfxtp_1
X_2062_ clknet_leaf_8_clk _0142_ VGND VGND VPWR VPWR uart_rx_raspi_inst.prescale_reg\[9\]
+ sky130_fd_sc_hd__dfxtp_1
X_2131_ clknet_leaf_22_clk _0211_ VGND VGND VPWR VPWR uart_rx_jetson_inst.prescale_reg\[3\]
+ sky130_fd_sc_hd__dfxtp_1
XFILLER_0_44_32 VGND VGND VPWR VPWR sky130_fd_sc_hd__decap_3
XFILLER_0_60_97 VPWR VGND VPWR VGND sky130_ef_sc_hd__decap_12
XFILLER_0_60_53 VGND VGND VPWR VPWR sky130_fd_sc_hd__decap_3
XFILLER_0_56_195 VGND VGND VPWR VPWR sky130_fd_sc_hd__fill_1
XFILLER_0_56_173 VGND VGND VPWR VPWR sky130_fd_sc_hd__fill_1
X_1915_ _0558_ VGND VGND VPWR VPWR _0109_ sky130_fd_sc_hd__inv_2
Xclkbuf_leaf_14_clk clknet_2_3__leaf_clk VGND VGND VPWR VPWR clknet_leaf_14_clk sky130_fd_sc_hd__clkbuf_16
X_1846_ _0933_ _0934_ net80 VGND VGND VPWR VPWR _0611_ sky130_fd_sc_hd__o21ai_1
XFILLER_0_8_43 VPWR VGND VPWR VGND sky130_ef_sc_hd__decap_12
XFILLER_0_12_221 VGND VGND VPWR VPWR sky130_fd_sc_hd__fill_1
X_1777_ net37 VGND VGND VPWR VPWR _0562_ sky130_fd_sc_hd__inv_2
XFILLER_0_7_281 VGND VGND VPWR VPWR sky130_fd_sc_hd__fill_1
XFILLER_0_14_24 VGND VGND VPWR VPWR sky130_fd_sc_hd__decap_4
XFILLER_0_53_165 VGND VGND VPWR VPWR sky130_fd_sc_hd__decap_3
XFILLER_0_53_121 VGND VGND VPWR VPWR sky130_fd_sc_hd__fill_1
XFILLER_0_26_346 VGND VGND VPWR VPWR sky130_fd_sc_hd__fill_1
X_1700_ _0469_ _0527_ _0504_ VGND VGND VPWR VPWR _0528_ sky130_fd_sc_hd__a21o_1
X_1631_ uart_rx_jetson_inst.prescale_reg\[17\] uart_rx_jetson_inst.prescale_reg\[16\]
+ _0473_ VGND VGND VPWR VPWR _0474_ sky130_fd_sc_hd__or3_4
X_1562_ _0428_ _0429_ _0414_ VGND VGND VPWR VPWR _0171_ sky130_fd_sc_hd__o21ba_1
X_1493_ uart_tx_jetson_inst.prescale_reg\[18\] _0372_ _0376_ _0377_ VGND VGND VPWR
+ VPWR _0378_ sky130_fd_sc_hd__and4bb_1
Xclkbuf_leaf_3_clk clknet_2_1__leaf_clk VGND VGND VPWR VPWR clknet_leaf_3_clk sky130_fd_sc_hd__clkbuf_16
XTAP_202 VGND VPWR sky130_fd_sc_hd__tapvpwrvgnd_1
XTAP_213 VGND VPWR sky130_fd_sc_hd__tapvpwrvgnd_1
XTAP_224 VGND VPWR sky130_fd_sc_hd__tapvpwrvgnd_1
XTAP_235 VGND VPWR sky130_fd_sc_hd__tapvpwrvgnd_1
XTAP_246 VGND VPWR sky130_fd_sc_hd__tapvpwrvgnd_1
XTAP_257 VGND VPWR sky130_fd_sc_hd__tapvpwrvgnd_1
XFILLER_0_55_86 VGND VGND VPWR VPWR sky130_fd_sc_hd__decap_6
XFILLER_0_55_64 VGND VGND VPWR VPWR sky130_fd_sc_hd__decap_3
X_2045_ clknet_leaf_10_clk _0125_ VGND VGND VPWR VPWR uart_rx_raspi_inst.m_axis_tdata_reg\[4\]
+ sky130_fd_sc_hd__dfxtp_1
X_2114_ clknet_leaf_7_clk _0194_ VGND VGND VPWR VPWR uart_rx_raspi_inst.data_reg\[6\]
+ sky130_fd_sc_hd__dfxtp_1
XTAP_279 VGND VPWR sky130_fd_sc_hd__tapvpwrvgnd_1
XTAP_268 VGND VPWR sky130_fd_sc_hd__tapvpwrvgnd_1
XFILLER_0_29_162 VGND VGND VPWR VPWR sky130_fd_sc_hd__decap_6
XFILLER_0_44_187 VGND VGND VPWR VPWR sky130_fd_sc_hd__decap_8
XFILLER_0_44_165 VGND VGND VPWR VPWR sky130_fd_sc_hd__decap_8
X_1829_ net239 _0598_ _0596_ VGND VGND VPWR VPWR _0269_ sky130_fd_sc_hd__o21a_1
XFILLER_0_4_284 VGND VGND VPWR VPWR sky130_fd_sc_hd__decap_3
XFILLER_0_4_251 VGND VGND VPWR VPWR sky130_fd_sc_hd__fill_1
XFILLER_0_35_187 VPWR VGND VPWR VGND sky130_ef_sc_hd__decap_12
X_1614_ _0461_ VGND VGND VPWR VPWR _0191_ sky130_fd_sc_hd__clkbuf_1
XFILLER_0_41_135 VGND VGND VPWR VPWR sky130_fd_sc_hd__decap_6
XFILLER_0_41_113 VGND VGND VPWR VPWR sky130_fd_sc_hd__fill_2
XFILLER_0_14_305 VGND VGND VPWR VPWR sky130_fd_sc_hd__decap_3
XFILLER_0_14_316 VGND VGND VPWR VPWR sky130_fd_sc_hd__decap_4
X_1545_ uart_tx_jetson_inst.prescale_reg\[8\] _0410_ net75 VGND VGND VPWR VPWR _0418_
+ sky130_fd_sc_hd__o21ai_1
X_1476_ uart_rx_raspi_inst.prescale_reg\[16\] _0969_ net64 VGND VGND VPWR VPWR _0365_
+ sky130_fd_sc_hd__o21ai_1
XFILLER_0_1_265 VPWR VGND VPWR VGND sky130_ef_sc_hd__decap_12
XFILLER_0_10_3 VPWR VGND VPWR VGND sky130_ef_sc_hd__decap_12
X_2028_ _0716_ VGND VGND VPWR VPWR _0322_ sky130_fd_sc_hd__clkbuf_1
XFILLER_0_11_25 VGND VGND VPWR VPWR sky130_fd_sc_hd__fill_2
XFILLER_0_11_69 VGND VGND VPWR VPWR sky130_fd_sc_hd__decap_6
X_1261_ dual_watchdog_inst.watchdog_fc.rising_edge_timeout.internal_count\[10\] dual_watchdog_inst.watchdog_fc.rising_edge_timeout.internal_count\[11\]
+ _0886_ VGND VGND VPWR VPWR _0894_ sky130_fd_sc_hd__and3_1
X_1330_ uart_rx_jetson_inst.m_axis_tdata_reg\[1\] uart_tx_raspi_inst.data_reg\[2\]
+ _0930_ VGND VGND VPWR VPWR _0947_ sky130_fd_sc_hd__mux2_1
XFILLER_0_36_33 VGND VGND VPWR VPWR sky130_fd_sc_hd__fill_1
X_1192_ dual_watchdog_inst.watchdog_fc.falling_edge_timeout.internal_count\[15\] dual_watchdog_inst.watchdog_fc.falling_edge_timeout.internal_count\[14\]
+ dual_watchdog_inst.watchdog_fc.falling_edge_timeout.internal_count\[16\] _0846_
+ VGND VGND VPWR VPWR _0850_ sky130_fd_sc_hd__nand4_1
XFILLER_0_52_98 VGND VGND VPWR VPWR sky130_fd_sc_hd__decap_8
XFILLER_0_46_205 VGND VGND VPWR VPWR sky130_fd_sc_hd__decap_8
XFILLER_0_58_3 VPWR VGND VPWR VGND sky130_ef_sc_hd__decap_12
X_1528_ uart_tx_jetson_inst.prescale_reg\[5\] _0402_ VGND VGND VPWR VPWR _0405_ sky130_fd_sc_hd__or2_1
X_1459_ _0999_ _0354_ _0328_ VGND VGND VPWR VPWR _0143_ sky130_fd_sc_hd__a21oi_1
XFILLER_0_37_249 VGND VGND VPWR VPWR sky130_fd_sc_hd__decap_4
XFILLER_0_9_162 VGND VGND VPWR VPWR sky130_fd_sc_hd__fill_1
XPHY_91 VGND VGND VPWR VPWR sky130_fd_sc_hd__decap_3
XPHY_80 VGND VGND VPWR VPWR sky130_fd_sc_hd__decap_3
XFILLER_0_3_349 VPWR VGND VPWR VGND sky130_ef_sc_hd__decap_12
XFILLER_0_3_305 VPWR VGND VPWR VGND sky130_ef_sc_hd__decap_12
XFILLER_0_11_116 VGND VGND VPWR VPWR sky130_fd_sc_hd__fill_1
X_1244_ dual_watchdog_inst.watchdog_fc.rising_edge_timeout.internal_count\[8\] _0882_
+ VGND VGND VPWR VPWR _0883_ sky130_fd_sc_hd__or2_1
XFILLER_0_47_65 VGND VGND VPWR VPWR sky130_fd_sc_hd__fill_1
X_1313_ uart_rx_jetson_inst.m_axis_tdata_reg\[0\] uart_tx_raspi_inst.data_reg\[1\]
+ _0930_ VGND VGND VPWR VPWR _0931_ sky130_fd_sc_hd__mux2_1
X_2293_ clknet_leaf_17_clk _0317_ VGND VGND VPWR VPWR uart_rx_jetson_inst.data_reg\[1\]
+ sky130_fd_sc_hd__dfxtp_1
X_1175_ dual_watchdog_inst.watchdog_fc.falling_edge_timeout.internal_count\[9\] dual_watchdog_inst.watchdog_fc.falling_edge_timeout.internal_count\[8\]
+ dual_watchdog_inst.watchdog_fc.falling_edge_timeout.internal_count\[10\] _0834_
+ VGND VGND VPWR VPWR _0839_ sky130_fd_sc_hd__and4_1
XFILLER_0_19_238 VGND VGND VPWR VPWR sky130_fd_sc_hd__decap_4
XFILLER_0_10_193 VGND VGND VPWR VPWR sky130_fd_sc_hd__decap_3
XFILLER_0_17_24 VGND VGND VPWR VPWR sky130_fd_sc_hd__fill_1
XFILLER_0_33_67 VGND VGND VPWR VPWR sky130_fd_sc_hd__decap_8
XFILLER_0_17_57 VPWR VGND VPWR VGND sky130_ef_sc_hd__decap_12
XFILLER_0_56_333 VPWR VGND VPWR VGND sky130_ef_sc_hd__decap_12
X_1793_ _0573_ net136 _0571_ VGND VGND VPWR VPWR _0574_ sky130_fd_sc_hd__mux2_1
X_1862_ net84 uart_tx_raspi_inst.prescale_reg\[13\] _0618_ VGND VGND VPWR VPWR _0621_
+ sky130_fd_sc_hd__or3_1
XFILLER_0_3_113 VPWR VGND VPWR VGND sky130_ef_sc_hd__decap_12
X_1931_ dual_watchdog_inst.watchdog_fc.falling_edge_timeout.assert_time\[4\] _0645_
+ VGND VGND VPWR VPWR _0650_ sky130_fd_sc_hd__and2_1
X_1227_ dual_watchdog_inst.watchdog_fc.rising_edge_timeout.internal_count\[1\] dual_watchdog_inst.watchdog_fc.rising_edge_timeout.internal_count\[0\]
+ dual_watchdog_inst.watchdog_fc.rising_edge_timeout.internal_count\[2\] VGND VGND
+ VPWR VPWR _0872_ sky130_fd_sc_hd__and3_1
X_2276_ clknet_leaf_27_clk _0301_ net7 VGND VGND VPWR VPWR dual_watchdog_inst.watchdog_fc.falling_edge_timeout.assert_time\[12\]
+ sky130_fd_sc_hd__dfrtp_1
X_1158_ dual_watchdog_inst.watchdog_fc.falling_edge_timeout.internal_count\[5\] dual_watchdog_inst.watchdog_fc.falling_edge_timeout.internal_count\[4\]
+ VGND VGND VPWR VPWR _0827_ sky130_fd_sc_hd__and2_1
X_1089_ dual_watchdog_inst.watchdog_fc.rising_edge_timeout.assert_time\[11\] _0743_
+ dual_watchdog_inst.watchdog_fc.rising_edge_timeout.assert_time\[12\] VGND VGND VPWR
+ VPWR _0777_ sky130_fd_sc_hd__a21o_1
XFILLER_0_57_108 VGND VGND VPWR VPWR sky130_fd_sc_hd__fill_1
XTAP_439 VGND VPWR sky130_fd_sc_hd__tapvpwrvgnd_1
XTAP_428 VGND VPWR sky130_fd_sc_hd__tapvpwrvgnd_1
XTAP_417 VGND VPWR sky130_fd_sc_hd__tapvpwrvgnd_1
XTAP_406 VGND VPWR sky130_fd_sc_hd__tapvpwrvgnd_1
X_2061_ clknet_leaf_0_clk _0141_ VGND VGND VPWR VPWR uart_rx_raspi_inst.prescale_reg\[8\]
+ sky130_fd_sc_hd__dfxtp_1
X_2130_ clknet_leaf_22_clk _0210_ VGND VGND VPWR VPWR uart_rx_jetson_inst.prescale_reg\[2\]
+ sky130_fd_sc_hd__dfxtp_1
XFILLER_0_56_141 VPWR VGND VPWR VGND sky130_ef_sc_hd__decap_12
XFILLER_0_56_130 VGND VGND VPWR VPWR sky130_fd_sc_hd__decap_8
X_1914_ _0558_ VGND VGND VPWR VPWR _0108_ sky130_fd_sc_hd__inv_2
XFILLER_0_44_325 VGND VGND VPWR VPWR sky130_fd_sc_hd__decap_3
X_1776_ _0561_ VGND VGND VPWR VPWR _0083_ sky130_fd_sc_hd__inv_2
X_1845_ uart_tx_raspi_inst.prescale_reg\[8\] _0933_ _0934_ VGND VGND VPWR VPWR _0610_
+ sky130_fd_sc_hd__or3_1
XFILLER_0_8_55 VGND VGND VPWR VPWR sky130_fd_sc_hd__fill_2
XFILLER_0_40_3 VGND VGND VPWR VPWR sky130_fd_sc_hd__decap_8
X_2259_ clknet_leaf_6_clk _0044_ _0106_ VGND VGND VPWR VPWR dual_watchdog_inst.watchdog_fc.rising_edge_timeout.internal_count\[22\]
+ sky130_fd_sc_hd__dfrtp_1
XFILLER_0_47_141 VPWR VGND VPWR VGND sky130_ef_sc_hd__decap_12
XFILLER_0_35_325 VGND VGND VPWR VPWR sky130_fd_sc_hd__decap_6
XFILLER_0_35_314 VGND VGND VPWR VPWR sky130_fd_sc_hd__decap_8
XFILLER_0_50_328 VGND VGND VPWR VPWR sky130_fd_sc_hd__decap_6
XFILLER_0_38_141 VGND VGND VPWR VPWR sky130_fd_sc_hd__decap_3
XFILLER_0_14_47 VGND VGND VPWR VPWR sky130_fd_sc_hd__fill_1
XFILLER_0_30_24 VGND VGND VPWR VPWR sky130_fd_sc_hd__decap_4
X_1630_ net50 uart_rx_jetson_inst.prescale_reg\[7\] _0470_ _0472_ VGND VGND VPWR VPWR
+ _0473_ sky130_fd_sc_hd__or4_4
X_1561_ uart_tx_jetson_inst.prescale_reg\[14\] _0427_ VGND VGND VPWR VPWR _0429_ sky130_fd_sc_hd__nor2_1
X_1492_ uart_tx_jetson_inst.prescale_reg\[17\] uart_tx_jetson_inst.prescale_reg\[16\]
+ VGND VGND VPWR VPWR _0377_ sky130_fd_sc_hd__nor2_1
XFILLER_0_39_99 VGND VGND VPWR VPWR sky130_fd_sc_hd__decap_6
XFILLER_0_39_11 VGND VGND VPWR VPWR sky130_fd_sc_hd__fill_2
XTAP_203 VGND VPWR sky130_fd_sc_hd__tapvpwrvgnd_1
XTAP_214 VGND VPWR sky130_fd_sc_hd__tapvpwrvgnd_1
XTAP_225 VGND VPWR sky130_fd_sc_hd__tapvpwrvgnd_1
XTAP_236 VGND VPWR sky130_fd_sc_hd__tapvpwrvgnd_1
XTAP_247 VGND VPWR sky130_fd_sc_hd__tapvpwrvgnd_1
XTAP_258 VGND VPWR sky130_fd_sc_hd__tapvpwrvgnd_1
XTAP_269 VGND VPWR sky130_fd_sc_hd__tapvpwrvgnd_1
X_2044_ clknet_leaf_11_clk _0124_ VGND VGND VPWR VPWR uart_rx_raspi_inst.m_axis_tdata_reg\[3\]
+ sky130_fd_sc_hd__dfxtp_1
X_2113_ clknet_leaf_7_clk _0193_ VGND VGND VPWR VPWR uart_rx_raspi_inst.data_reg\[5\]
+ sky130_fd_sc_hd__dfxtp_1
XFILLER_0_32_306 VGND VGND VPWR VPWR sky130_fd_sc_hd__fill_2
X_1759_ _0560_ VGND VGND VPWR VPWR _0067_ sky130_fd_sc_hd__inv_2
X_1828_ _0933_ _0597_ _0565_ VGND VGND VPWR VPWR _0598_ sky130_fd_sc_hd__a21oi_1
XFILLER_0_50_169 VGND VGND VPWR VPWR sky130_fd_sc_hd__fill_1
XFILLER_0_31_361 VGND VGND VPWR VPWR sky130_fd_sc_hd__fill_1
XFILLER_0_25_46 VGND VGND VPWR VPWR sky130_fd_sc_hd__decap_8
XFILLER_0_41_23 VGND VGND VPWR VPWR sky130_fd_sc_hd__decap_4
XFILLER_0_26_111 VGND VGND VPWR VPWR sky130_fd_sc_hd__fill_1
X_1613_ _0460_ net189 _0454_ VGND VGND VPWR VPWR _0461_ sky130_fd_sc_hd__mux2_1
X_1544_ uart_tx_jetson_inst.prescale_reg\[9\] _0415_ VGND VGND VPWR VPWR _0417_ sky130_fd_sc_hd__or2_1
XFILLER_0_1_277 VGND VGND VPWR VPWR sky130_fd_sc_hd__decap_3
X_1475_ _0363_ _0364_ _0345_ VGND VGND VPWR VPWR _0149_ sky130_fd_sc_hd__a21oi_1
X_2027_ _0715_ net206 _0703_ VGND VGND VPWR VPWR _0716_ sky130_fd_sc_hd__mux2_1
XFILLER_0_40_191 VGND VGND VPWR VPWR sky130_fd_sc_hd__decap_4
XFILLER_0_20_309 VGND VGND VPWR VPWR sky130_fd_sc_hd__decap_4
XFILLER_0_11_15 VGND VGND VPWR VPWR sky130_fd_sc_hd__decap_4
XFILLER_0_23_147 VGND VGND VPWR VPWR sky130_fd_sc_hd__fill_1
XFILLER_0_23_169 VPWR VGND VPWR VGND sky130_ef_sc_hd__decap_12
X_1260_ net90 _0892_ VGND VGND VPWR VPWR _0034_ sky130_fd_sc_hd__xnor2_1
X_1191_ _0848_ _0849_ VGND VGND VPWR VPWR _0009_ sky130_fd_sc_hd__nor2_1
XFILLER_0_52_11 VGND VGND VPWR VPWR sky130_fd_sc_hd__fill_2
X_1527_ _0389_ _0404_ _0399_ VGND VGND VPWR VPWR _0161_ sky130_fd_sc_hd__a21oi_1
X_1389_ _0986_ _0991_ VGND VGND VPWR VPWR _0992_ sky130_fd_sc_hd__and2b_1
X_1458_ _0352_ _0353_ net18 VGND VGND VPWR VPWR _0354_ sky130_fd_sc_hd__o21ai_1
XFILLER_0_37_217 VGND VGND VPWR VPWR sky130_fd_sc_hd__fill_2
XFILLER_0_60_253 VPWR VGND VPWR VGND sky130_ef_sc_hd__decap_12
XFILLER_0_20_106 VGND VGND VPWR VPWR sky130_fd_sc_hd__fill_2
XPHY_92 VGND VGND VPWR VPWR sky130_fd_sc_hd__decap_3
XPHY_81 VGND VGND VPWR VPWR sky130_fd_sc_hd__decap_3
XPHY_70 VGND VGND VPWR VPWR sky130_fd_sc_hd__decap_3
XFILLER_0_3_317 VPWR VGND VPWR VGND sky130_ef_sc_hd__decap_12
XFILLER_0_11_106 VGND VGND VPWR VPWR sky130_fd_sc_hd__decap_6
XFILLER_0_11_139 VPWR VGND VPWR VGND sky130_ef_sc_hd__decap_12
X_1243_ dual_watchdog_inst.watchdog_fc.rising_edge_timeout.internal_count\[7\] dual_watchdog_inst.watchdog_fc.rising_edge_timeout.internal_count\[6\]
+ _0875_ _0877_ VGND VGND VPWR VPWR _0882_ sky130_fd_sc_hd__and4_1
XFILLER_0_47_44 VGND VGND VPWR VPWR sky130_fd_sc_hd__decap_3
X_2292_ clknet_leaf_17_clk _0316_ VGND VGND VPWR VPWR uart_rx_jetson_inst.data_reg\[0\]
+ sky130_fd_sc_hd__dfxtp_1
X_1174_ net133 _0837_ VGND VGND VPWR VPWR _0838_ sky130_fd_sc_hd__nor2_1
X_1312_ _0929_ VGND VGND VPWR VPWR _0930_ sky130_fd_sc_hd__clkbuf_4
XFILLER_0_42_253 VPWR VGND VPWR VGND sky130_ef_sc_hd__decap_12
XFILLER_0_2_361 VGND VGND VPWR VPWR sky130_fd_sc_hd__fill_1
XFILLER_0_33_220 VGND VGND VPWR VPWR sky130_fd_sc_hd__decap_4
XFILLER_0_18_250 VGND VGND VPWR VPWR sky130_fd_sc_hd__fill_2
XFILLER_0_18_261 VGND VGND VPWR VPWR sky130_fd_sc_hd__decap_4
XFILLER_0_33_275 VGND VGND VPWR VPWR sky130_fd_sc_hd__decap_4
XFILLER_0_0_309 VPWR VGND VPWR VGND sky130_ef_sc_hd__decap_12
XFILLER_0_56_345 VPWR VGND VPWR VGND sky130_ef_sc_hd__decap_12
XFILLER_0_33_57 VGND VGND VPWR VPWR sky130_fd_sc_hd__decap_6
X_1930_ dual_watchdog_inst.watchdog_fc.falling_edge_timeout.assert_time\[4\] _0645_
+ VGND VGND VPWR VPWR _0649_ sky130_fd_sc_hd__nor2_1
X_1792_ uart_rx_raspi_inst.m_axis_tdata_reg\[1\] uart_tx_jetson_inst.data_reg\[2\]
+ _0383_ VGND VGND VPWR VPWR _0573_ sky130_fd_sc_hd__mux2_1
X_1861_ _0609_ _0620_ VGND VGND VPWR VPWR _0279_ sky130_fd_sc_hd__nor2_1
XFILLER_0_3_158 VGND VGND VPWR VPWR sky130_fd_sc_hd__fill_1
X_1226_ net95 net61 VGND VGND VPWR VPWR _0041_ sky130_fd_sc_hd__xor2_1
X_2275_ clknet_leaf_27_clk _0300_ net7 VGND VGND VPWR VPWR dual_watchdog_inst.watchdog_fc.falling_edge_timeout.assert_time\[11\]
+ sky130_fd_sc_hd__dfrtp_1
X_1157_ net89 _0825_ VGND VGND VPWR VPWR _0024_ sky130_fd_sc_hd__xor2_1
X_1088_ net87 _0775_ _0776_ VGND VGND VPWR VPWR _0240_ sky130_fd_sc_hd__o21a_1
XFILLER_0_30_245 VGND VGND VPWR VPWR sky130_fd_sc_hd__decap_6
XFILLER_0_15_297 VGND VGND VPWR VPWR sky130_fd_sc_hd__decap_3
XFILLER_0_53_337 VPWR VGND VPWR VGND sky130_ef_sc_hd__decap_12
XTAP_429 VGND VPWR sky130_fd_sc_hd__tapvpwrvgnd_1
XTAP_418 VGND VPWR sky130_fd_sc_hd__tapvpwrvgnd_1
XTAP_407 VGND VPWR sky130_fd_sc_hd__tapvpwrvgnd_1
X_2060_ clknet_leaf_1_clk _0140_ VGND VGND VPWR VPWR uart_rx_raspi_inst.prescale_reg\[7\]
+ sky130_fd_sc_hd__dfxtp_1
XFILLER_0_56_197 VGND VGND VPWR VPWR sky130_fd_sc_hd__decap_8
XFILLER_0_56_153 VPWR VGND VPWR VGND sky130_ef_sc_hd__decap_12
XFILLER_0_56_120 VGND VGND VPWR VPWR sky130_fd_sc_hd__fill_2
X_1913_ _0558_ VGND VGND VPWR VPWR _0107_ sky130_fd_sc_hd__inv_2
XFILLER_0_29_334 VGND VGND VPWR VPWR sky130_fd_sc_hd__fill_2
X_1775_ _0561_ VGND VGND VPWR VPWR _0082_ sky130_fd_sc_hd__inv_2
X_1844_ _0606_ _0607_ _0609_ VGND VGND VPWR VPWR _0273_ sky130_fd_sc_hd__o21ba_1
XFILLER_0_8_23 VGND VGND VPWR VPWR sky130_fd_sc_hd__decap_4
X_2258_ clknet_leaf_6_clk _0043_ _0105_ VGND VGND VPWR VPWR dual_watchdog_inst.watchdog_fc.rising_edge_timeout.internal_count\[21\]
+ sky130_fd_sc_hd__dfrtp_1
XFILLER_0_33_3 VGND VGND VPWR VPWR sky130_fd_sc_hd__decap_6
X_2189_ clknet_leaf_18_clk _0269_ VGND VGND VPWR VPWR uart_tx_raspi_inst.prescale_reg\[3\]
+ sky130_fd_sc_hd__dfxtp_1
X_1209_ _0798_ _0857_ _0858_ VGND VGND VPWR VPWR _0861_ sky130_fd_sc_hd__or3_1
XFILLER_0_47_153 VPWR VGND VPWR VGND sky130_ef_sc_hd__decap_12
XFILLER_0_35_359 VGND VGND VPWR VPWR sky130_fd_sc_hd__decap_3
XFILLER_0_35_337 VGND VGND VPWR VPWR sky130_fd_sc_hd__decap_3
XFILLER_0_38_197 VGND VGND VPWR VPWR sky130_fd_sc_hd__decap_3
X_1560_ net235 _0427_ VGND VGND VPWR VPWR _0428_ sky130_fd_sc_hd__and2_1
XFILLER_0_53_145 VPWR VGND VPWR VGND sky130_ef_sc_hd__decap_12
XFILLER_0_30_69 VGND VGND VPWR VPWR sky130_fd_sc_hd__decap_4
X_2112_ clknet_leaf_7_clk _0192_ VGND VGND VPWR VPWR uart_rx_raspi_inst.data_reg\[4\]
+ sky130_fd_sc_hd__dfxtp_1
X_1491_ uart_tx_jetson_inst.prescale_reg\[12\] _0373_ _0374_ _0375_ VGND VGND VPWR
+ VPWR _0376_ sky130_fd_sc_hd__nor4_1
XTAP_204 VGND VPWR sky130_fd_sc_hd__tapvpwrvgnd_1
XTAP_215 VGND VPWR sky130_fd_sc_hd__tapvpwrvgnd_1
XTAP_226 VGND VPWR sky130_fd_sc_hd__tapvpwrvgnd_1
XTAP_237 VGND VPWR sky130_fd_sc_hd__tapvpwrvgnd_1
XTAP_248 VGND VPWR sky130_fd_sc_hd__tapvpwrvgnd_1
XTAP_259 VGND VPWR sky130_fd_sc_hd__tapvpwrvgnd_1
X_2043_ clknet_leaf_11_clk _0123_ VGND VGND VPWR VPWR uart_rx_raspi_inst.m_axis_tdata_reg\[2\]
+ sky130_fd_sc_hd__dfxtp_1
XFILLER_0_55_55 VGND VGND VPWR VPWR sky130_fd_sc_hd__fill_1
X_1827_ uart_tx_raspi_inst.prescale_reg\[3\] _0593_ VGND VGND VPWR VPWR _0597_ sky130_fd_sc_hd__nand2_1
XFILLER_0_17_315 VGND VGND VPWR VPWR sky130_fd_sc_hd__fill_1
X_1758_ _0558_ VGND VGND VPWR VPWR _0560_ sky130_fd_sc_hd__buf_4
XFILLER_0_4_264 VGND VGND VPWR VPWR sky130_fd_sc_hd__fill_1
XFILLER_0_4_253 VGND VGND VPWR VPWR sky130_fd_sc_hd__fill_1
X_1689_ _0519_ VGND VGND VPWR VPWR _0520_ sky130_fd_sc_hd__buf_2
XFILLER_0_41_57 VGND VGND VPWR VPWR sky130_fd_sc_hd__decap_8
XFILLER_0_26_178 VGND VGND VPWR VPWR sky130_fd_sc_hd__decap_3
XFILLER_0_26_145 VGND VGND VPWR VPWR sky130_fd_sc_hd__fill_1
X_1612_ uart_rx_raspi_inst.data_reg\[4\] _0974_ VGND VGND VPWR VPWR _0460_ sky130_fd_sc_hd__and2_1
X_1543_ _0415_ _0416_ _0414_ VGND VGND VPWR VPWR _0165_ sky130_fd_sc_hd__a21oi_1
X_1474_ net81 _0969_ VGND VGND VPWR VPWR _0364_ sky130_fd_sc_hd__nand2_1
XFILLER_0_57_281 VPWR VGND VPWR VGND sky130_ef_sc_hd__decap_12
XFILLER_0_9_301 VGND VGND VPWR VPWR sky130_fd_sc_hd__fill_1
XFILLER_0_9_323 VPWR VGND VPWR VGND sky130_ef_sc_hd__decap_12
X_2026_ uart_rx_jetson_inst.data_reg\[7\] _0501_ VGND VGND VPWR VPWR _0715_ sky130_fd_sc_hd__and2_1
XFILLER_0_48_292 VGND VGND VPWR VPWR sky130_fd_sc_hd__decap_6
X_1190_ dual_watchdog_inst.watchdog_fc.falling_edge_timeout.internal_count\[15\] dual_watchdog_inst.watchdog_fc.falling_edge_timeout.internal_count\[14\]
+ _0845_ VGND VGND VPWR VPWR _0849_ sky130_fd_sc_hd__and3_1
XFILLER_0_52_34 VGND VGND VPWR VPWR sky130_fd_sc_hd__decap_8
XFILLER_0_39_292 VPWR VGND VPWR VGND sky130_ef_sc_hd__decap_12
XFILLER_0_14_115 VGND VGND VPWR VPWR sky130_fd_sc_hd__fill_1
XFILLER_0_14_137 VGND VGND VPWR VPWR sky130_fd_sc_hd__decap_3
X_1526_ _0402_ _0403_ _0379_ VGND VGND VPWR VPWR _0404_ sky130_fd_sc_hd__a21o_1
X_1457_ uart_rx_raspi_inst.prescale_reg\[9\] _0349_ uart_rx_raspi_inst.prescale_reg\[10\]
+ VGND VGND VPWR VPWR _0353_ sky130_fd_sc_hd__o21a_1
XFILLER_0_22_181 VGND VGND VPWR VPWR sky130_fd_sc_hd__decap_8
X_1388_ uart_rx_raspi_inst.data_reg\[6\] uart_rx_raspi_inst.m_axis_tdata_reg\[6\]
+ net17 VGND VGND VPWR VPWR _0991_ sky130_fd_sc_hd__mux2_2
X_2009_ _0702_ net155 _0703_ VGND VGND VPWR VPWR _0704_ sky130_fd_sc_hd__mux2_1
XFILLER_0_60_265 VPWR VGND VPWR VGND sky130_ef_sc_hd__decap_12
XFILLER_0_45_295 VPWR VGND VPWR VGND sky130_ef_sc_hd__decap_12
XPHY_82 VGND VGND VPWR VPWR sky130_fd_sc_hd__decap_3
XPHY_71 VGND VGND VPWR VPWR sky130_fd_sc_hd__decap_3
XPHY_60 VGND VGND VPWR VPWR sky130_fd_sc_hd__decap_3
XFILLER_0_22_15 VGND VGND VPWR VPWR sky130_fd_sc_hd__fill_2
XFILLER_0_51_265 VPWR VGND VPWR VGND sky130_ef_sc_hd__decap_12
XPHY_93 VGND VGND VPWR VPWR sky130_fd_sc_hd__decap_3
XFILLER_0_36_251 VGND VGND VPWR VPWR sky130_fd_sc_hd__fill_1
XFILLER_0_3_329 VGND VGND VPWR VPWR sky130_fd_sc_hd__decap_6
X_1311_ uart_tx_raspi_inst.bit_cnt\[3\] uart_tx_raspi_inst.bit_cnt\[2\] uart_tx_raspi_inst.bit_cnt\[1\]
+ uart_tx_raspi_inst.bit_cnt\[0\] VGND VGND VPWR VPWR _0929_ sky130_fd_sc_hd__or4_1
X_2291_ clknet_leaf_29_clk _0001_ _0111_ VGND VGND VPWR VPWR dual_watchdog_inst.watchdog_fc.rising_edge_timeout.tcnt
+ sky130_fd_sc_hd__dfrtp_1
X_1242_ net39 _0880_ VGND VGND VPWR VPWR _0054_ sky130_fd_sc_hd__xnor2_1
XFILLER_0_47_89 VGND VGND VPWR VPWR sky130_fd_sc_hd__fill_1
X_1173_ _0836_ _0837_ VGND VGND VPWR VPWR _0029_ sky130_fd_sc_hd__nor2_1
XFILLER_0_6_134 VGND VGND VPWR VPWR sky130_fd_sc_hd__decap_3
XFILLER_0_42_265 VGND VGND VPWR VPWR sky130_fd_sc_hd__decap_4
X_1509_ _0371_ VGND VGND VPWR VPWR _0391_ sky130_fd_sc_hd__inv_2
XFILLER_0_56_357 VGND VGND VPWR VPWR sky130_fd_sc_hd__decap_4
X_1860_ net142 _0618_ VGND VGND VPWR VPWR _0620_ sky130_fd_sc_hd__xor2_1
Xclkbuf_leaf_26_clk clknet_2_0__leaf_clk VGND VGND VPWR VPWR clknet_leaf_26_clk sky130_fd_sc_hd__clkbuf_16
X_1791_ _0572_ VGND VGND VPWR VPWR _0257_ sky130_fd_sc_hd__clkbuf_1
XFILLER_0_24_221 VPWR VGND VPWR VGND sky130_ef_sc_hd__decap_12
XFILLER_0_24_265 VGND VGND VPWR VPWR sky130_fd_sc_hd__decap_4
XFILLER_0_58_77 VGND VGND VPWR VPWR sky130_fd_sc_hd__fill_1
X_2274_ clknet_leaf_27_clk _0299_ net7 VGND VGND VPWR VPWR dual_watchdog_inst.watchdog_fc.falling_edge_timeout.assert_time\[10\]
+ sky130_fd_sc_hd__dfrtp_1
XFILLER_0_59_140 VPWR VGND VPWR VGND sky130_ef_sc_hd__decap_12
X_1225_ net61 _0759_ VGND VGND VPWR VPWR _0030_ sky130_fd_sc_hd__nor2_1
X_1087_ _0764_ _0745_ VGND VGND VPWR VPWR _0776_ sky130_fd_sc_hd__nor2_1
Xclkbuf_leaf_17_clk clknet_2_2__leaf_clk VGND VGND VPWR VPWR clknet_leaf_17_clk sky130_fd_sc_hd__clkbuf_16
X_1156_ _0825_ _0826_ VGND VGND VPWR VPWR _0023_ sky130_fd_sc_hd__nor2_1
XFILLER_0_47_335 VGND VGND VPWR VPWR sky130_fd_sc_hd__fill_1
X_1989_ _0829_ _0688_ _0689_ VGND VGND VPWR VPWR _0690_ sky130_fd_sc_hd__and3_1
XFILLER_0_53_349 VPWR VGND VPWR VGND sky130_ef_sc_hd__decap_12
XFILLER_0_21_213 VGND VGND VPWR VPWR sky130_fd_sc_hd__decap_8
XTAP_419 VGND VPWR sky130_fd_sc_hd__tapvpwrvgnd_1
XTAP_408 VGND VPWR sky130_fd_sc_hd__tapvpwrvgnd_1
XFILLER_0_60_78 VGND VGND VPWR VPWR sky130_fd_sc_hd__fill_1
XFILLER_0_56_165 VGND VGND VPWR VPWR sky130_fd_sc_hd__decap_8
X_1912_ _0639_ VGND VGND VPWR VPWR _0106_ sky130_fd_sc_hd__inv_2
XFILLER_0_44_305 VGND VGND VPWR VPWR sky130_fd_sc_hd__decap_3
X_1843_ _0608_ VGND VGND VPWR VPWR _0609_ sky130_fd_sc_hd__buf_2
XFILLER_0_29_324 VGND VGND VPWR VPWR sky130_fd_sc_hd__decap_3
Xclkbuf_leaf_6_clk clknet_2_1__leaf_clk VGND VGND VPWR VPWR clknet_leaf_6_clk sky130_fd_sc_hd__clkbuf_16
X_1774_ _0561_ VGND VGND VPWR VPWR _0081_ sky130_fd_sc_hd__inv_2
XFILLER_0_12_213 VGND VGND VPWR VPWR sky130_fd_sc_hd__decap_8
X_2257_ clknet_leaf_6_clk _0042_ _0104_ VGND VGND VPWR VPWR dual_watchdog_inst.watchdog_fc.rising_edge_timeout.internal_count\[20\]
+ sky130_fd_sc_hd__dfrtp_2
XFILLER_0_18_91 VGND VGND VPWR VPWR sky130_fd_sc_hd__fill_1
X_1208_ dual_watchdog_inst.watchdog_fc.falling_edge_timeout.internal_count\[21\] dual_watchdog_inst.watchdog_fc.falling_edge_timeout.internal_count\[20\]
+ _0855_ dual_watchdog_inst.watchdog_fc.falling_edge_timeout.internal_count\[22\]
+ VGND VGND VPWR VPWR _0860_ sky130_fd_sc_hd__a31o_1
XFILLER_0_47_165 VGND VGND VPWR VPWR sky130_fd_sc_hd__decap_3
XFILLER_0_47_110 VGND VGND VPWR VPWR sky130_fd_sc_hd__fill_2
X_2188_ clknet_leaf_18_clk _0268_ VGND VGND VPWR VPWR uart_tx_raspi_inst.prescale_reg\[2\]
+ sky130_fd_sc_hd__dfxtp_1
X_1139_ dual_watchdog_inst.watchdog_fc.falling_edge_timeout.assert_time\[1\] dual_watchdog_inst.watchdog_fc.falling_edge_timeout.assert_time\[3\]
+ dual_watchdog_inst.watchdog_fc.falling_edge_timeout.assert_time\[2\] dual_watchdog_inst.watchdog_fc.falling_edge_timeout.assert_time\[0\]
+ VGND VGND VPWR VPWR _0814_ sky130_fd_sc_hd__or4bb_1
XFILLER_0_43_360 VGND VGND VPWR VPWR sky130_fd_sc_hd__fill_2
XFILLER_0_53_157 VGND VGND VPWR VPWR sky130_fd_sc_hd__decap_8
X_1490_ uart_tx_jetson_inst.prescale_reg\[11\] uart_tx_jetson_inst.prescale_reg\[10\]
+ uart_tx_jetson_inst.prescale_reg\[9\] uart_tx_jetson_inst.prescale_reg\[8\] VGND
+ VGND VPWR VPWR _0375_ sky130_fd_sc_hd__or4_1
XFILLER_0_41_319 VGND VGND VPWR VPWR sky130_fd_sc_hd__decap_3
XFILLER_0_39_57 VGND VGND VPWR VPWR sky130_fd_sc_hd__fill_1
XTAP_205 VGND VPWR sky130_fd_sc_hd__tapvpwrvgnd_1
X_2042_ clknet_leaf_11_clk _0122_ VGND VGND VPWR VPWR uart_rx_raspi_inst.m_axis_tdata_reg\[1\]
+ sky130_fd_sc_hd__dfxtp_1
X_2111_ clknet_leaf_7_clk _0191_ VGND VGND VPWR VPWR uart_rx_raspi_inst.data_reg\[3\]
+ sky130_fd_sc_hd__dfxtp_1
XFILLER_0_39_79 VGND VGND VPWR VPWR sky130_fd_sc_hd__fill_1
XTAP_216 VGND VPWR sky130_fd_sc_hd__tapvpwrvgnd_1
XTAP_227 VGND VPWR sky130_fd_sc_hd__tapvpwrvgnd_1
XTAP_238 VGND VPWR sky130_fd_sc_hd__tapvpwrvgnd_1
XTAP_249 VGND VPWR sky130_fd_sc_hd__tapvpwrvgnd_1
XFILLER_0_29_121 VGND VGND VPWR VPWR sky130_fd_sc_hd__fill_2
XFILLER_0_44_102 VGND VGND VPWR VPWR sky130_fd_sc_hd__decap_4
X_1826_ net239 _0595_ _0596_ VGND VGND VPWR VPWR _0268_ sky130_fd_sc_hd__o21a_1
XFILLER_0_25_360 VGND VGND VPWR VPWR sky130_fd_sc_hd__fill_2
XFILLER_0_4_210 VGND VGND VPWR VPWR sky130_fd_sc_hd__fill_1
X_1757_ _0559_ VGND VGND VPWR VPWR _0066_ sky130_fd_sc_hd__inv_2
X_1688_ uart_rst _0518_ VGND VGND VPWR VPWR _0519_ sky130_fd_sc_hd__or2_1
XFILLER_0_50_127 VGND VGND VPWR VPWR sky130_fd_sc_hd__fill_1
XFILLER_0_50_105 VGND VGND VPWR VPWR sky130_fd_sc_hd__decap_6
XFILLER_0_58_238 VPWR VGND VPWR VGND sky130_ef_sc_hd__decap_12
XFILLER_0_25_15 VGND VGND VPWR VPWR sky130_fd_sc_hd__decap_8
X_1611_ _0459_ VGND VGND VPWR VPWR _0190_ sky130_fd_sc_hd__clkbuf_1
X_1542_ net77 _0410_ VGND VGND VPWR VPWR _0416_ sky130_fd_sc_hd__nand2_1
X_1473_ net81 _0969_ VGND VGND VPWR VPWR _0363_ sky130_fd_sc_hd__or2_1
X_2025_ _0714_ VGND VGND VPWR VPWR _0321_ sky130_fd_sc_hd__clkbuf_1
XFILLER_0_57_293 VPWR VGND VPWR VGND sky130_ef_sc_hd__decap_12
XFILLER_0_49_238 VGND VGND VPWR VPWR sky130_fd_sc_hd__fill_1
XFILLER_0_49_216 VGND VGND VPWR VPWR sky130_fd_sc_hd__fill_1
XFILLER_0_9_335 VGND VGND VPWR VPWR sky130_fd_sc_hd__fill_1
XFILLER_0_9_357 VGND VGND VPWR VPWR sky130_fd_sc_hd__decap_4
XFILLER_0_17_113 VGND VGND VPWR VPWR sky130_fd_sc_hd__decap_3
X_1809_ _0584_ VGND VGND VPWR VPWR _0263_ sky130_fd_sc_hd__clkbuf_1
XFILLER_0_40_171 VGND VGND VPWR VPWR sky130_fd_sc_hd__decap_4
XFILLER_0_32_116 VGND VGND VPWR VPWR sky130_fd_sc_hd__fill_1
XFILLER_0_13_352 VGND VGND VPWR VPWR sky130_fd_sc_hd__fill_2
Xhold220 dual_watchdog_inst.watchdog_fc.falling_edge_timeout.internal_count\[20\]
+ VGND VGND VPWR VPWR net234 sky130_fd_sc_hd__dlygate4sd3_1
XFILLER_0_48_282 VGND VGND VPWR VPWR sky130_fd_sc_hd__fill_2
XFILLER_0_23_105 VGND VGND VPWR VPWR sky130_fd_sc_hd__decap_6
XFILLER_0_46_219 VPWR VGND VPWR VGND sky130_ef_sc_hd__decap_12
X_1387_ _0990_ VGND VGND VPWR VPWR _0126_ sky130_fd_sc_hd__clkbuf_1
X_1525_ uart_tx_jetson_inst.prescale_reg\[4\] _0373_ VGND VGND VPWR VPWR _0403_ sky130_fd_sc_hd__nand2_1
X_1456_ uart_rx_raspi_inst.prescale_reg\[10\] uart_rx_raspi_inst.prescale_reg\[9\]
+ _0349_ VGND VGND VPWR VPWR _0352_ sky130_fd_sc_hd__nor3_1
X_2008_ uart_rx_jetson_inst.bit_cnt\[0\] _0476_ _0497_ _0507_ uart_rst VGND VGND VPWR
+ VPWR _0703_ sky130_fd_sc_hd__a2111o_4
XFILLER_0_60_277 VGND VGND VPWR VPWR sky130_fd_sc_hd__decap_3
XFILLER_0_60_233 VGND VGND VPWR VPWR sky130_fd_sc_hd__fill_1
XPHY_94 VGND VGND VPWR VPWR sky130_fd_sc_hd__decap_3
XPHY_83 VGND VGND VPWR VPWR sky130_fd_sc_hd__decap_3
XPHY_72 VGND VGND VPWR VPWR sky130_fd_sc_hd__decap_3
XPHY_61 VGND VGND VPWR VPWR sky130_fd_sc_hd__decap_3
XFILLER_0_22_27 VGND VGND VPWR VPWR sky130_fd_sc_hd__fill_1
XPHY_50 VGND VGND VPWR VPWR sky130_fd_sc_hd__decap_3
XFILLER_0_47_57 VGND VGND VPWR VPWR sky130_fd_sc_hd__decap_4
X_1241_ _0881_ VGND VGND VPWR VPWR _0053_ sky130_fd_sc_hd__clkbuf_1
X_2290_ clknet_leaf_0_clk _0315_ net12 VGND VGND VPWR VPWR dual_watchdog_inst.watchdog_fc.falling_edge_timeout.assert_time\[26\]
+ sky130_fd_sc_hd__dfrtp_1
X_1310_ dual_watchdog_inst.watchdog_fc.falling_edge_timeout.tcnt dual_watchdog_inst.watchdog_fc.rising_edge_timeout.tcnt
+ VGND VGND VPWR VPWR net4 sky130_fd_sc_hd__nor2_1
X_1172_ dual_watchdog_inst.watchdog_fc.falling_edge_timeout.internal_count\[9\] dual_watchdog_inst.watchdog_fc.falling_edge_timeout.internal_count\[8\]
+ _0834_ VGND VGND VPWR VPWR _0837_ sky130_fd_sc_hd__and3_1
XFILLER_0_2_15 VPWR VGND VPWR VGND sky130_ef_sc_hd__decap_12
XFILLER_0_27_241 VGND VGND VPWR VPWR sky130_fd_sc_hd__fill_1
XFILLER_0_6_168 VPWR VGND VPWR VGND sky130_ef_sc_hd__decap_12
XFILLER_0_56_3 VPWR VGND VPWR VGND sky130_ef_sc_hd__decap_12
XFILLER_0_10_141 VGND VGND VPWR VPWR sky130_fd_sc_hd__fill_1
XFILLER_0_12_93 VGND VGND VPWR VPWR sky130_fd_sc_hd__fill_2
X_1508_ uart_tx_jetson_inst.prescale_reg\[0\] _0379_ VGND VGND VPWR VPWR _0390_ sky130_fd_sc_hd__or2_1
XFILLER_0_37_90 VGND VGND VPWR VPWR sky130_fd_sc_hd__fill_2
X_1439_ uart_rx_raspi_inst.prescale_reg\[5\] _0337_ VGND VGND VPWR VPWR _0340_ sky130_fd_sc_hd__or2_1
XFILLER_0_56_303 VGND VGND VPWR VPWR sky130_fd_sc_hd__decap_4
X_1790_ _0569_ net163 _0571_ VGND VGND VPWR VPWR _0572_ sky130_fd_sc_hd__mux2_1
XFILLER_0_3_138 VGND VGND VPWR VPWR sky130_fd_sc_hd__fill_2
XFILLER_0_3_105 VGND VGND VPWR VPWR sky130_fd_sc_hd__decap_6
XFILLER_0_24_233 VGND VGND VPWR VPWR sky130_fd_sc_hd__fill_1
X_2273_ clknet_leaf_28_clk net148 net7 VGND VGND VPWR VPWR dual_watchdog_inst.watchdog_fc.falling_edge_timeout.assert_time\[9\]
+ sky130_fd_sc_hd__dfrtp_1
X_1224_ _0871_ VGND VGND VPWR VPWR _0021_ sky130_fd_sc_hd__clkbuf_1
XFILLER_0_59_152 VPWR VGND VPWR VGND sky130_ef_sc_hd__decap_12
XFILLER_0_47_314 VGND VGND VPWR VPWR sky130_fd_sc_hd__decap_8
X_1086_ dual_watchdog_inst.watchdog_fc.rising_edge_timeout.assert_time\[12\] dual_watchdog_inst.watchdog_fc.rising_edge_timeout.assert_time\[11\]
+ _0743_ VGND VGND VPWR VPWR _0775_ sky130_fd_sc_hd__and3_1
X_1155_ net91 _0822_ VGND VGND VPWR VPWR _0826_ sky130_fd_sc_hd__nor2_1
XFILLER_0_30_203 VGND VGND VPWR VPWR sky130_fd_sc_hd__decap_4
XFILLER_0_15_222 VGND VGND VPWR VPWR sky130_fd_sc_hd__fill_2
X_1988_ net158 _0686_ VGND VGND VPWR VPWR _0689_ sky130_fd_sc_hd__nand2_1
Xclkbuf_2_2__f_clk clknet_0_clk VGND VGND VPWR VPWR clknet_2_2__leaf_clk sky130_fd_sc_hd__clkbuf_16
XFILLER_0_21_225 VPWR VGND VPWR VGND sky130_ef_sc_hd__decap_12
XFILLER_0_21_247 VGND VGND VPWR VPWR sky130_fd_sc_hd__fill_2
XFILLER_0_21_258 VGND VGND VPWR VPWR sky130_fd_sc_hd__decap_6
XTAP_409 VGND VPWR sky130_fd_sc_hd__tapvpwrvgnd_1
XFILLER_0_28_15 VGND VGND VPWR VPWR sky130_fd_sc_hd__decap_6
XFILLER_0_60_57 VPWR VGND VPWR VGND sky130_ef_sc_hd__decap_12
XFILLER_0_52_361 VGND VGND VPWR VPWR sky130_fd_sc_hd__fill_1
X_1911_ _0639_ VGND VGND VPWR VPWR _0105_ sky130_fd_sc_hd__inv_2
X_1773_ _0561_ VGND VGND VPWR VPWR _0080_ sky130_fd_sc_hd__inv_2
X_1842_ uart_rst _0565_ VGND VGND VPWR VPWR _0608_ sky130_fd_sc_hd__or2_1
XFILLER_0_12_258 VGND VGND VPWR VPWR sky130_fd_sc_hd__fill_1
XFILLER_0_20_291 VGND VGND VPWR VPWR sky130_fd_sc_hd__fill_1
X_2256_ clknet_leaf_6_clk _0040_ _0103_ VGND VGND VPWR VPWR dual_watchdog_inst.watchdog_fc.rising_edge_timeout.internal_count\[19\]
+ sky130_fd_sc_hd__dfrtp_2
X_2187_ clknet_leaf_16_clk _0267_ VGND VGND VPWR VPWR uart_tx_raspi_inst.prescale_reg\[1\]
+ sky130_fd_sc_hd__dfxtp_2
XFILLER_0_19_3 VPWR VGND VPWR VGND sky130_ef_sc_hd__decap_12
X_1207_ _0857_ _0858_ _0859_ _0841_ VGND VGND VPWR VPWR _0016_ sky130_fd_sc_hd__o211a_1
X_1069_ dual_watchdog_inst.watchdog_fc.rising_edge_timeout.assert_time\[20\] _0754_
+ _0764_ VGND VGND VPWR VPWR _0765_ sky130_fd_sc_hd__a21oi_1
XFILLER_0_34_80 VGND VGND VPWR VPWR sky130_fd_sc_hd__decap_4
X_1138_ dual_watchdog_inst.watchdog_fc.falling_edge_timeout.assert_time\[5\] dual_watchdog_inst.watchdog_fc.falling_edge_timeout.assert_time\[4\]
+ dual_watchdog_inst.watchdog_fc.falling_edge_timeout.assert_time\[7\] dual_watchdog_inst.watchdog_fc.falling_edge_timeout.assert_time\[6\]
+ VGND VGND VPWR VPWR _0813_ sky130_fd_sc_hd__or4_1
XFILLER_0_7_274 VGND VGND VPWR VPWR sky130_fd_sc_hd__decap_6
XFILLER_0_38_177 VGND VGND VPWR VPWR sky130_fd_sc_hd__decap_8
XFILLER_0_26_306 VGND VGND VPWR VPWR sky130_fd_sc_hd__fill_2
XTAP_206 VGND VPWR sky130_fd_sc_hd__tapvpwrvgnd_1
XTAP_217 VGND VPWR sky130_fd_sc_hd__tapvpwrvgnd_1
XTAP_228 VGND VPWR sky130_fd_sc_hd__tapvpwrvgnd_1
XTAP_239 VGND VPWR sky130_fd_sc_hd__tapvpwrvgnd_1
X_2110_ clknet_leaf_7_clk _0190_ VGND VGND VPWR VPWR uart_rx_raspi_inst.data_reg\[2\]
+ sky130_fd_sc_hd__dfxtp_1
X_2041_ clknet_leaf_11_clk _0121_ VGND VGND VPWR VPWR uart_rx_raspi_inst.m_axis_tdata_reg\[0\]
+ sky130_fd_sc_hd__dfxtp_1
XFILLER_0_44_136 VGND VGND VPWR VPWR sky130_fd_sc_hd__decap_4
XFILLER_0_32_309 VPWR VGND VPWR VGND sky130_ef_sc_hd__decap_12
X_1825_ _0963_ _0589_ VGND VGND VPWR VPWR _0596_ sky130_fd_sc_hd__nor2b_1
X_1756_ _0559_ VGND VGND VPWR VPWR _0065_ sky130_fd_sc_hd__inv_2
XFILLER_0_4_233 VGND VGND VPWR VPWR sky130_fd_sc_hd__fill_2
X_1687_ uart_rx_jetson_inst.rxd_reg uart_rx_jetson_inst.bit_cnt\[0\] _0475_ _0476_
+ VGND VGND VPWR VPWR _0518_ sky130_fd_sc_hd__o211a_1
X_2239_ clknet_leaf_3_clk _0049_ _0086_ VGND VGND VPWR VPWR dual_watchdog_inst.watchdog_fc.rising_edge_timeout.internal_count\[2\]
+ sky130_fd_sc_hd__dfrtp_1
XFILLER_0_0_81 VGND VGND VPWR VPWR sky130_fd_sc_hd__decap_3
X_1610_ _0458_ net175 _0454_ VGND VGND VPWR VPWR _0459_ sky130_fd_sc_hd__mux2_1
XFILLER_0_14_309 VGND VGND VPWR VPWR sky130_fd_sc_hd__decap_4
X_1541_ net77 _0410_ VGND VGND VPWR VPWR _0415_ sky130_fd_sc_hd__or2_1
X_1472_ _0969_ _0362_ _0345_ VGND VGND VPWR VPWR _0148_ sky130_fd_sc_hd__a21oi_1
X_2024_ _0713_ net197 _0703_ VGND VGND VPWR VPWR _0714_ sky130_fd_sc_hd__mux2_1
XFILLER_0_9_314 VGND VGND VPWR VPWR sky130_fd_sc_hd__decap_3
Xhold221 uart_tx_jetson_inst.prescale_reg\[14\] VGND VGND VPWR VPWR net235 sky130_fd_sc_hd__dlygate4sd3_1
X_1808_ _0583_ net124 _0571_ VGND VGND VPWR VPWR _0584_ sky130_fd_sc_hd__mux2_1
Xhold210 uart_rx_raspi_inst.prescale_reg\[3\] VGND VGND VPWR VPWR net224 sky130_fd_sc_hd__dlygate4sd3_1
X_1739_ net69 _0473_ VGND VGND VPWR VPWR _0554_ sky130_fd_sc_hd__or2_1
XFILLER_0_36_15 VGND VGND VPWR VPWR sky130_fd_sc_hd__decap_6
XFILLER_0_54_242 VGND VGND VPWR VPWR sky130_fd_sc_hd__fill_1
XFILLER_0_6_306 VGND VGND VPWR VPWR sky130_fd_sc_hd__fill_2
X_1524_ uart_tx_jetson_inst.prescale_reg\[4\] _0373_ VGND VGND VPWR VPWR _0402_ sky130_fd_sc_hd__or2_1
XFILLER_0_22_194 VGND VGND VPWR VPWR sky130_fd_sc_hd__fill_2
X_1386_ _0986_ _0989_ VGND VGND VPWR VPWR _0990_ sky130_fd_sc_hd__and2b_1
X_1455_ _1001_ _0974_ _0328_ _0351_ VGND VGND VPWR VPWR _0142_ sky130_fd_sc_hd__a211oi_1
X_2007_ uart_rx_jetson_inst.data_reg\[1\] _0501_ VGND VGND VPWR VPWR _0702_ sky130_fd_sc_hd__and2_1
XFILLER_0_60_223 VGND VGND VPWR VPWR sky130_fd_sc_hd__fill_1
XFILLER_0_5_361 VGND VGND VPWR VPWR sky130_fd_sc_hd__fill_1
XFILLER_0_9_199 VGND VGND VPWR VPWR sky130_fd_sc_hd__fill_1
XFILLER_0_6_80 VGND VGND VPWR VPWR sky130_fd_sc_hd__decap_4
XPHY_95 VGND VGND VPWR VPWR sky130_fd_sc_hd__decap_3
XPHY_84 VGND VGND VPWR VPWR sky130_fd_sc_hd__decap_3
XPHY_73 VGND VGND VPWR VPWR sky130_fd_sc_hd__decap_3
XPHY_62 VGND VGND VPWR VPWR sky130_fd_sc_hd__decap_3
XPHY_51 VGND VGND VPWR VPWR sky130_fd_sc_hd__decap_3
XPHY_40 VGND VGND VPWR VPWR sky130_fd_sc_hd__decap_3
XFILLER_0_51_223 VGND VGND VPWR VPWR sky130_fd_sc_hd__fill_1
X_1240_ _0738_ _0879_ _0880_ VGND VGND VPWR VPWR _0881_ sky130_fd_sc_hd__and3_1
X_1171_ dual_watchdog_inst.watchdog_fc.falling_edge_timeout.internal_count\[8\] _0834_
+ net167 VGND VGND VPWR VPWR _0836_ sky130_fd_sc_hd__a21oi_1
XFILLER_0_2_27 VGND VGND VPWR VPWR sky130_fd_sc_hd__fill_1
XFILLER_0_42_245 VGND VGND VPWR VPWR sky130_fd_sc_hd__fill_2
XFILLER_0_12_72 VGND VGND VPWR VPWR sky130_fd_sc_hd__fill_2
X_1507_ _0388_ _0369_ _0379_ VGND VGND VPWR VPWR _0389_ sky130_fd_sc_hd__o21ai_4
X_1369_ uart_rx_raspi_inst.data_reg\[0\] uart_rx_raspi_inst.m_axis_tdata_reg\[0\]
+ _0977_ VGND VGND VPWR VPWR _0978_ sky130_fd_sc_hd__mux2_1
XFILLER_0_49_3 VGND VGND VPWR VPWR sky130_fd_sc_hd__decap_8
X_1438_ _0998_ _0339_ _0328_ VGND VGND VPWR VPWR _0137_ sky130_fd_sc_hd__a21oi_1
X_2272_ clknet_leaf_28_clk _0297_ net7 VGND VGND VPWR VPWR dual_watchdog_inst.watchdog_fc.falling_edge_timeout.assert_time\[8\]
+ sky130_fd_sc_hd__dfrtp_1
X_1154_ _0824_ VGND VGND VPWR VPWR _0825_ sky130_fd_sc_hd__clkbuf_2
X_1223_ _0829_ _0869_ _0870_ VGND VGND VPWR VPWR _0871_ sky130_fd_sc_hd__and3_1
XFILLER_0_59_164 VGND VGND VPWR VPWR sky130_fd_sc_hd__decap_4
X_1085_ net66 _0745_ _0774_ VGND VGND VPWR VPWR _0241_ sky130_fd_sc_hd__o21a_1
XFILLER_0_15_278 VGND VGND VPWR VPWR sky130_fd_sc_hd__fill_2
X_1987_ dual_watchdog_inst.watchdog_fc.falling_edge_timeout.assert_time\[22\] _0686_
+ VGND VGND VPWR VPWR _0688_ sky130_fd_sc_hd__or2_1
XFILLER_0_3_81 VPWR VGND VPWR VGND sky130_ef_sc_hd__decap_12
XFILLER_0_0_109 VGND VGND VPWR VPWR sky130_fd_sc_hd__decap_3
XFILLER_0_21_237 VGND VGND VPWR VPWR sky130_fd_sc_hd__fill_1
XFILLER_0_56_112 VGND VGND VPWR VPWR sky130_fd_sc_hd__decap_8
X_1910_ _0639_ VGND VGND VPWR VPWR _0104_ sky130_fd_sc_hd__inv_2
XFILLER_0_29_337 VGND VGND VPWR VPWR sky130_fd_sc_hd__decap_3
X_1772_ _0561_ VGND VGND VPWR VPWR _0079_ sky130_fd_sc_hd__inv_2
X_1841_ uart_tx_raspi_inst.prescale_reg\[6\] _0602_ net161 VGND VGND VPWR VPWR _0607_
+ sky130_fd_sc_hd__o21a_1
X_2255_ clknet_leaf_6_clk _0039_ _0102_ VGND VGND VPWR VPWR dual_watchdog_inst.watchdog_fc.rising_edge_timeout.internal_count\[18\]
+ sky130_fd_sc_hd__dfrtp_1
X_2186_ clknet_leaf_18_clk _0266_ VGND VGND VPWR VPWR uart_tx_raspi_inst.prescale_reg\[0\]
+ sky130_fd_sc_hd__dfxtp_1
X_1137_ dual_watchdog_inst.watchdog_fc.falling_edge_timeout.assert_time\[17\] dual_watchdog_inst.watchdog_fc.falling_edge_timeout.assert_time\[16\]
+ dual_watchdog_inst.watchdog_fc.falling_edge_timeout.assert_time\[19\] dual_watchdog_inst.watchdog_fc.falling_edge_timeout.assert_time\[18\]
+ VGND VGND VPWR VPWR _0812_ sky130_fd_sc_hd__or4_1
X_1206_ dual_watchdog_inst.watchdog_fc.falling_edge_timeout.internal_count\[20\] _0855_
+ dual_watchdog_inst.watchdog_fc.falling_edge_timeout.internal_count\[21\] VGND VGND
+ VPWR VPWR _0859_ sky130_fd_sc_hd__a21o_1
X_1068_ _0758_ VGND VGND VPWR VPWR _0764_ sky130_fd_sc_hd__clkbuf_4
XFILLER_0_35_307 VGND VGND VPWR VPWR sky130_fd_sc_hd__decap_3
XFILLER_0_7_253 VGND VGND VPWR VPWR sky130_fd_sc_hd__fill_1
XFILLER_0_43_340 VPWR VGND VPWR VGND sky130_ef_sc_hd__decap_12
XFILLER_0_7_286 VGND VGND VPWR VPWR sky130_fd_sc_hd__decap_8
XFILLER_0_11_281 VGND VGND VPWR VPWR sky130_fd_sc_hd__decap_3
XFILLER_0_14_18 VGND VGND VPWR VPWR sky130_fd_sc_hd__fill_1
XFILLER_0_14_29 VPWR VGND VPWR VGND sky130_ef_sc_hd__decap_12
XTAP_207 VGND VPWR sky130_fd_sc_hd__tapvpwrvgnd_1
XTAP_218 VGND VPWR sky130_fd_sc_hd__tapvpwrvgnd_1
XTAP_229 VGND VPWR sky130_fd_sc_hd__tapvpwrvgnd_1
X_2040_ clknet_leaf_19_clk _0120_ VGND VGND VPWR VPWR uart_tx_raspi_inst.data_reg\[8\]
+ sky130_fd_sc_hd__dfxtp_1
XFILLER_0_29_178 VGND VGND VPWR VPWR sky130_fd_sc_hd__fill_1
X_1824_ _0593_ _0594_ _0565_ VGND VGND VPWR VPWR _0595_ sky130_fd_sc_hd__a21oi_1
X_1755_ _0559_ VGND VGND VPWR VPWR _0064_ sky130_fd_sc_hd__inv_2
XFILLER_0_4_223 VGND VGND VPWR VPWR sky130_fd_sc_hd__fill_2
X_1686_ net201 _0504_ VGND VGND VPWR VPWR _0517_ sky130_fd_sc_hd__or2_1
X_2238_ clknet_leaf_4_clk _0041_ _0085_ VGND VGND VPWR VPWR dual_watchdog_inst.watchdog_fc.rising_edge_timeout.internal_count\[1\]
+ sky130_fd_sc_hd__dfrtp_1
XFILLER_0_31_3 VGND VGND VPWR VPWR sky130_fd_sc_hd__decap_8
X_2169_ clknet_leaf_3_clk _0249_ _0079_ VGND VGND VPWR VPWR dual_watchdog_inst.watchdog_fc.rising_edge_timeout.assert_time\[22\]
+ sky130_fd_sc_hd__dfrtp_1
XFILLER_0_41_27 VGND VGND VPWR VPWR sky130_fd_sc_hd__fill_1
X_1540_ _0411_ _0412_ _0414_ VGND VGND VPWR VPWR _0164_ sky130_fd_sc_hd__o21ba_1
X_1471_ _0346_ _0968_ net55 VGND VGND VPWR VPWR _0362_ sky130_fd_sc_hd__o21ai_1
XFILLER_0_15_50 VGND VGND VPWR VPWR sky130_fd_sc_hd__fill_1
X_2023_ uart_rx_jetson_inst.data_reg\[6\] _0501_ VGND VGND VPWR VPWR _0713_ sky130_fd_sc_hd__and2_1
X_1807_ uart_rx_raspi_inst.m_axis_tdata_reg\[6\] uart_tx_jetson_inst.data_reg\[7\]
+ _0383_ VGND VGND VPWR VPWR _0583_ sky130_fd_sc_hd__mux2_1
XFILLER_0_9_348 VGND VGND VPWR VPWR sky130_fd_sc_hd__fill_1
XFILLER_0_13_310 VGND VGND VPWR VPWR sky130_fd_sc_hd__decap_6
XFILLER_0_17_159 VGND VGND VPWR VPWR sky130_fd_sc_hd__decap_4
Xhold222 uart_rx_raspi_inst.prescale_reg\[2\] VGND VGND VPWR VPWR net236 sky130_fd_sc_hd__dlygate4sd3_1
Xhold211 uart_tx_jetson_inst.prescale_reg\[3\] VGND VGND VPWR VPWR net225 sky130_fd_sc_hd__dlygate4sd3_1
XFILLER_0_40_195 VGND VGND VPWR VPWR sky130_fd_sc_hd__fill_1
Xhold200 uart_tx_raspi_inst.prescale_reg\[9\] VGND VGND VPWR VPWR net214 sky130_fd_sc_hd__dlygate4sd3_1
XFILLER_0_0_281 VPWR VGND VPWR VGND sky130_ef_sc_hd__decap_12
X_1738_ _0473_ _0553_ _0536_ VGND VGND VPWR VPWR _0223_ sky130_fd_sc_hd__a21oi_1
X_1669_ _0475_ VGND VGND VPWR VPWR _0504_ sky130_fd_sc_hd__buf_2
XFILLER_0_11_19 VGND VGND VPWR VPWR sky130_fd_sc_hd__fill_1
XFILLER_0_54_221 VGND VGND VPWR VPWR sky130_fd_sc_hd__fill_2
X_1523_ _0389_ _0401_ _0399_ VGND VGND VPWR VPWR _0160_ sky130_fd_sc_hd__a21oi_1
X_1454_ uart_rx_raspi_inst.prescale_reg\[9\] _0349_ VGND VGND VPWR VPWR _0351_ sky130_fd_sc_hd__xor2_1
XFILLER_0_10_335 VGND VGND VPWR VPWR sky130_fd_sc_hd__fill_2
X_1385_ uart_rx_raspi_inst.data_reg\[5\] uart_rx_raspi_inst.m_axis_tdata_reg\[5\]
+ net17 VGND VGND VPWR VPWR _0989_ sky130_fd_sc_hd__mux2_2
XFILLER_0_45_221 VGND VGND VPWR VPWR sky130_fd_sc_hd__decap_3
XFILLER_0_42_70 VGND VGND VPWR VPWR sky130_fd_sc_hd__fill_1
X_2006_ _0558_ VGND VGND VPWR VPWR _0111_ sky130_fd_sc_hd__inv_2
XTAP_390 VGND VPWR sky130_fd_sc_hd__tapvpwrvgnd_1
XPHY_30 VGND VGND VPWR VPWR sky130_fd_sc_hd__decap_3
XPHY_96 VGND VGND VPWR VPWR sky130_fd_sc_hd__decap_3
XPHY_85 VGND VGND VPWR VPWR sky130_fd_sc_hd__decap_3
XPHY_74 VGND VGND VPWR VPWR sky130_fd_sc_hd__decap_3
XFILLER_0_36_243 VGND VGND VPWR VPWR sky130_fd_sc_hd__decap_8
XPHY_63 VGND VGND VPWR VPWR sky130_fd_sc_hd__decap_3
XPHY_52 VGND VGND VPWR VPWR sky130_fd_sc_hd__decap_3
XPHY_41 VGND VGND VPWR VPWR sky130_fd_sc_hd__decap_3
XFILLER_0_47_26 VPWR VGND VPWR VGND sky130_ef_sc_hd__decap_12
X_1170_ net138 _0834_ _0835_ _0821_ VGND VGND VPWR VPWR _0028_ sky130_fd_sc_hd__a211oi_1
XFILLER_0_59_335 VGND VGND VPWR VPWR sky130_fd_sc_hd__fill_1
Xclkbuf_leaf_29_clk clknet_2_0__leaf_clk VGND VGND VPWR VPWR clknet_leaf_29_clk sky130_fd_sc_hd__clkbuf_16
XFILLER_0_42_279 VPWR VGND VPWR VGND sky130_ef_sc_hd__decap_12
XFILLER_0_42_213 VPWR VGND VPWR VGND sky130_ef_sc_hd__decap_12
XFILLER_0_6_126 VGND VGND VPWR VPWR sky130_fd_sc_hd__decap_8
XFILLER_0_2_321 VPWR VGND VPWR VGND sky130_ef_sc_hd__decap_12
X_1506_ uart_tx_jetson_inst.bit_cnt\[0\] VGND VGND VPWR VPWR _0388_ sky130_fd_sc_hd__inv_2
X_1437_ _0337_ _0338_ _1001_ VGND VGND VPWR VPWR _0339_ sky130_fd_sc_hd__a21o_1
X_1299_ dual_watchdog_inst.watchdog_fc.rising_edge_timeout.internal_count\[24\] _0919_
+ dual_watchdog_inst.watchdog_fc.rising_edge_timeout.internal_count\[25\] VGND VGND
+ VPWR VPWR _0921_ sky130_fd_sc_hd__a21oi_1
X_1368_ _0976_ VGND VGND VPWR VPWR _0977_ sky130_fd_sc_hd__buf_6
XFILLER_0_53_91 VGND VGND VPWR VPWR sky130_fd_sc_hd__decap_4
XFILLER_0_33_202 VGND VGND VPWR VPWR sky130_fd_sc_hd__fill_1
XFILLER_0_33_279 VGND VGND VPWR VPWR sky130_fd_sc_hd__fill_1
XFILLER_0_18_298 VGND VGND VPWR VPWR sky130_fd_sc_hd__fill_1
XFILLER_0_24_213 VGND VGND VPWR VPWR sky130_fd_sc_hd__decap_4
X_2271_ clknet_leaf_28_clk _0296_ net7 VGND VGND VPWR VPWR dual_watchdog_inst.watchdog_fc.falling_edge_timeout.assert_time\[7\]
+ sky130_fd_sc_hd__dfrtp_1
X_1084_ net171 _0745_ _0764_ VGND VGND VPWR VPWR _0774_ sky130_fd_sc_hd__a21oi_1
X_1153_ dual_watchdog_inst.watchdog_fc.falling_edge_timeout.internal_count\[1\] dual_watchdog_inst.watchdog_fc.falling_edge_timeout.internal_count\[0\]
+ dual_watchdog_inst.watchdog_fc.falling_edge_timeout.internal_count\[3\] dual_watchdog_inst.watchdog_fc.falling_edge_timeout.internal_count\[2\]
+ VGND VGND VPWR VPWR _0824_ sky130_fd_sc_hd__and4_1
X_1222_ dual_watchdog_inst.watchdog_fc.falling_edge_timeout.internal_count\[25\] dual_watchdog_inst.watchdog_fc.falling_edge_timeout.internal_count\[24\]
+ dual_watchdog_inst.watchdog_fc.falling_edge_timeout.internal_count\[26\] _0866_
+ VGND VGND VPWR VPWR _0870_ sky130_fd_sc_hd__nand4_1
X_1986_ net152 _0684_ _0687_ _0829_ VGND VGND VPWR VPWR _0310_ sky130_fd_sc_hd__o211a_1
Xclkbuf_leaf_9_clk clknet_2_3__leaf_clk VGND VGND VPWR VPWR clknet_leaf_9_clk sky130_fd_sc_hd__clkbuf_16
XFILLER_0_30_216 VGND VGND VPWR VPWR sky130_fd_sc_hd__decap_6
XFILLER_0_3_93 VPWR VGND VPWR VGND sky130_ef_sc_hd__decap_12
XFILLER_0_14_290 VGND VGND VPWR VPWR sky130_fd_sc_hd__decap_3
XFILLER_0_44_38 VGND VGND VPWR VPWR sky130_fd_sc_hd__decap_4
XFILLER_0_60_15 VPWR VGND VPWR VGND sky130_ef_sc_hd__decap_12
X_1840_ _0933_ _0934_ VGND VGND VPWR VPWR _0606_ sky130_fd_sc_hd__nor2_1
XFILLER_0_29_349 VGND VGND VPWR VPWR sky130_fd_sc_hd__decap_4
X_1771_ _0561_ VGND VGND VPWR VPWR _0078_ sky130_fd_sc_hd__inv_2
XFILLER_0_8_27 VGND VGND VPWR VPWR sky130_fd_sc_hd__fill_1
XFILLER_0_12_238 VGND VGND VPWR VPWR sky130_fd_sc_hd__decap_4
X_2254_ clknet_leaf_5_clk _0038_ _0101_ VGND VGND VPWR VPWR dual_watchdog_inst.watchdog_fc.rising_edge_timeout.internal_count\[17\]
+ sky130_fd_sc_hd__dfrtp_1
X_2185_ clknet_leaf_9_clk _0265_ VGND VGND VPWR VPWR uart_tx_jetson_inst.data_reg\[8\]
+ sky130_fd_sc_hd__dfxtp_1
X_1067_ net125 dual_watchdog_inst.watchdog_fc.rising_edge_timeout.assert_time\[20\]
+ _0754_ _0763_ _0759_ VGND VGND VPWR VPWR _0248_ sky130_fd_sc_hd__a311oi_1
X_1205_ dual_watchdog_inst.watchdog_fc.falling_edge_timeout.internal_count\[19\] dual_watchdog_inst.watchdog_fc.falling_edge_timeout.internal_count\[18\]
+ _0853_ VGND VGND VPWR VPWR _0858_ sky130_fd_sc_hd__nand3_1
XFILLER_0_18_83 VGND VGND VPWR VPWR sky130_fd_sc_hd__fill_1
X_1136_ dual_watchdog_inst.watchdog_fc.falling_edge_timeout.assert_time\[21\] dual_watchdog_inst.watchdog_fc.falling_edge_timeout.assert_time\[20\]
+ dual_watchdog_inst.watchdog_fc.falling_edge_timeout.assert_time\[23\] dual_watchdog_inst.watchdog_fc.falling_edge_timeout.assert_time\[22\]
+ VGND VGND VPWR VPWR _0811_ sky130_fd_sc_hd__or4_1
XFILLER_0_50_81 VGND VGND VPWR VPWR sky130_fd_sc_hd__decap_3
XFILLER_0_43_352 VGND VGND VPWR VPWR sky130_fd_sc_hd__decap_8
X_1969_ _0674_ _0672_ _0676_ _0820_ VGND VGND VPWR VPWR _0304_ sky130_fd_sc_hd__a211oi_1
XFILLER_0_30_29 VGND VGND VPWR VPWR sky130_fd_sc_hd__decap_6
XFILLER_0_39_16 VGND VGND VPWR VPWR sky130_fd_sc_hd__decap_3
XTAP_208 VGND VPWR sky130_fd_sc_hd__tapvpwrvgnd_1
XTAP_219 VGND VPWR sky130_fd_sc_hd__tapvpwrvgnd_1
X_1823_ uart_tx_raspi_inst.prescale_reg\[1\] uart_tx_raspi_inst.prescale_reg\[0\]
+ uart_tx_raspi_inst.prescale_reg\[2\] VGND VGND VPWR VPWR _0594_ sky130_fd_sc_hd__o21ai_1
XFILLER_0_29_113 VGND VGND VPWR VPWR sky130_fd_sc_hd__decap_8
XFILLER_0_52_193 VGND VGND VPWR VPWR sky130_fd_sc_hd__decap_3
X_1754_ _0559_ VGND VGND VPWR VPWR _0063_ sky130_fd_sc_hd__inv_2
X_1685_ _1009_ _0516_ VGND VGND VPWR VPWR _0207_ sky130_fd_sc_hd__nor2_1
X_2237_ clknet_leaf_4_clk _0030_ _0084_ VGND VGND VPWR VPWR dual_watchdog_inst.watchdog_fc.rising_edge_timeout.internal_count\[0\]
+ sky130_fd_sc_hd__dfrtp_1
XFILLER_0_24_3 VPWR VGND VPWR VGND sky130_ef_sc_hd__decap_12
XFILLER_0_45_70 VGND VGND VPWR VPWR sky130_fd_sc_hd__fill_1
X_2099_ clknet_leaf_16_clk _0179_ VGND VGND VPWR VPWR uart_tx_jetson_inst.bit_cnt\[3\]
+ sky130_fd_sc_hd__dfxtp_1
X_2168_ clknet_leaf_2_clk net126 _0078_ VGND VGND VPWR VPWR dual_watchdog_inst.watchdog_fc.rising_edge_timeout.assert_time\[21\]
+ sky130_fd_sc_hd__dfrtp_1
X_1119_ _0726_ dual_watchdog_inst.watchdog_fc.rising_edge_timeout.assert_time\[0\]
+ VGND VGND VPWR VPWR _0796_ sky130_fd_sc_hd__and2b_1
XFILLER_0_43_182 VGND VGND VPWR VPWR sky130_fd_sc_hd__decap_6
XFILLER_0_35_149 VGND VGND VPWR VPWR sky130_fd_sc_hd__decap_3
XFILLER_0_31_311 VPWR VGND VPWR VGND sky130_ef_sc_hd__decap_12
XFILLER_0_58_208 VGND VGND VPWR VPWR sky130_fd_sc_hd__decap_4
XFILLER_0_26_138 VGND VGND VPWR VPWR sky130_fd_sc_hd__fill_2
X_1470_ _0345_ _0361_ VGND VGND VPWR VPWR _0147_ sky130_fd_sc_hd__nor2_1
XFILLER_0_1_205 VPWR VGND VPWR VGND sky130_ef_sc_hd__decap_12
X_2022_ _0712_ VGND VGND VPWR VPWR _0320_ sky130_fd_sc_hd__clkbuf_1
X_1806_ _0582_ VGND VGND VPWR VPWR _0262_ sky130_fd_sc_hd__clkbuf_1
Xhold201 dual_watchdog_inst.watchdog_fc.falling_edge_timeout.internal_count\[24\]
+ VGND VGND VPWR VPWR net215 sky130_fd_sc_hd__dlygate4sd3_1
Xhold212 dual_watchdog_inst.watchdog_fc.rising_edge_timeout.internal_count\[20\] VGND
+ VGND VPWR VPWR net226 sky130_fd_sc_hd__dlygate4sd3_1
Xhold223 uart_tx_raspi_inst.prescale_reg\[13\] VGND VGND VPWR VPWR net237 sky130_fd_sc_hd__dlygate4sd3_1
XFILLER_0_40_141 VGND VGND VPWR VPWR sky130_fd_sc_hd__decap_3
XFILLER_0_0_293 VPWR VGND VPWR VGND sky130_ef_sc_hd__decap_12
X_1737_ _0537_ _0472_ net50 VGND VGND VPWR VPWR _0553_ sky130_fd_sc_hd__o21ai_1
X_1599_ net52 _0928_ VGND VGND VPWR VPWR _0451_ sky130_fd_sc_hd__or2_1
X_1668_ uart_rx_jetson_inst.rxd_reg _0476_ uart_rx_jetson_inst.bit_cnt\[0\] VGND VGND
+ VPWR VPWR _0503_ sky130_fd_sc_hd__a21o_1
XFILLER_0_48_274 VGND VGND VPWR VPWR sky130_fd_sc_hd__decap_8
XFILLER_0_16_193 VGND VGND VPWR VPWR sky130_fd_sc_hd__decap_3
XFILLER_0_52_49 VPWR VGND VPWR VGND sky130_ef_sc_hd__decap_12
XFILLER_0_52_27 VGND VGND VPWR VPWR sky130_fd_sc_hd__fill_1
XFILLER_0_52_16 VGND VGND VPWR VPWR sky130_fd_sc_hd__decap_8
XFILLER_0_39_274 VGND VGND VPWR VPWR sky130_fd_sc_hd__fill_1
X_1522_ _0373_ _0400_ _0379_ VGND VGND VPWR VPWR _0401_ sky130_fd_sc_hd__a21o_1
X_1453_ _0349_ _0350_ _0345_ VGND VGND VPWR VPWR _0141_ sky130_fd_sc_hd__a21oi_1
XFILLER_0_22_141 VPWR VGND VPWR VGND sky130_ef_sc_hd__decap_12
X_1384_ _0988_ VGND VGND VPWR VPWR _0125_ sky130_fd_sc_hd__clkbuf_1
XFILLER_0_26_83 VGND VGND VPWR VPWR sky130_fd_sc_hd__fill_1
X_2005_ _0701_ VGND VGND VPWR VPWR _0315_ sky130_fd_sc_hd__clkbuf_1
XFILLER_0_42_93 VGND VGND VPWR VPWR sky130_fd_sc_hd__fill_2
XFILLER_0_9_113 VGND VGND VPWR VPWR sky130_fd_sc_hd__fill_2
XFILLER_0_9_135 VGND VGND VPWR VPWR sky130_fd_sc_hd__decap_4
XFILLER_0_60_225 VGND VGND VPWR VPWR sky130_fd_sc_hd__decap_8
XFILLER_0_45_288 VGND VGND VPWR VPWR sky130_fd_sc_hd__fill_2
XFILLER_0_5_330 VGND VGND VPWR VPWR sky130_fd_sc_hd__decap_6
XTAP_391 VGND VPWR sky130_fd_sc_hd__tapvpwrvgnd_1
XTAP_380 VGND VPWR sky130_fd_sc_hd__tapvpwrvgnd_1
XFILLER_0_6_71 VGND VGND VPWR VPWR sky130_fd_sc_hd__fill_1
XPHY_64 VGND VGND VPWR VPWR sky130_fd_sc_hd__decap_3
XPHY_53 VGND VGND VPWR VPWR sky130_fd_sc_hd__decap_3
XPHY_20 VGND VGND VPWR VPWR sky130_fd_sc_hd__decap_3
XPHY_31 VGND VGND VPWR VPWR sky130_fd_sc_hd__decap_3
XPHY_42 VGND VGND VPWR VPWR sky130_fd_sc_hd__decap_3
XPHY_97 VGND VGND VPWR VPWR sky130_fd_sc_hd__decap_3
XPHY_86 VGND VGND VPWR VPWR sky130_fd_sc_hd__decap_3
XPHY_75 VGND VGND VPWR VPWR sky130_fd_sc_hd__decap_3
XFILLER_0_8_190 VGND VGND VPWR VPWR sky130_fd_sc_hd__decap_6
XFILLER_0_47_38 VGND VGND VPWR VPWR sky130_fd_sc_hd__fill_1
XFILLER_0_2_29 VPWR VGND VPWR VGND sky130_ef_sc_hd__decap_12
XFILLER_0_6_116 VGND VGND VPWR VPWR sky130_fd_sc_hd__decap_3
XFILLER_0_42_225 VPWR VGND VPWR VGND sky130_ef_sc_hd__decap_12
XFILLER_0_27_277 VGND VGND VPWR VPWR sky130_fd_sc_hd__decap_3
XFILLER_0_2_333 VPWR VGND VPWR VGND sky130_ef_sc_hd__decap_12
XFILLER_0_12_85 VGND VGND VPWR VPWR sky130_fd_sc_hd__decap_8
XFILLER_0_50_291 VGND VGND VPWR VPWR sky130_fd_sc_hd__fill_1
X_1367_ _0972_ _0973_ _0975_ VGND VGND VPWR VPWR _0976_ sky130_fd_sc_hd__or3b_4
X_1505_ _0387_ VGND VGND VPWR VPWR _0156_ sky130_fd_sc_hd__clkbuf_1
X_1436_ uart_rx_raspi_inst.prescale_reg\[4\] net30 VGND VGND VPWR VPWR _0338_ sky130_fd_sc_hd__nand2_1
XFILLER_0_53_81 VGND VGND VPWR VPWR sky130_fd_sc_hd__decap_6
X_1298_ net205 _0919_ _0920_ VGND VGND VPWR VPWR _0046_ sky130_fd_sc_hd__o21a_1
XFILLER_0_58_15 VPWR VGND VPWR VGND sky130_ef_sc_hd__decap_12
X_2270_ clknet_leaf_28_clk _0295_ net7 VGND VGND VPWR VPWR dual_watchdog_inst.watchdog_fc.falling_edge_timeout.assert_time\[6\]
+ sky130_fd_sc_hd__dfrtp_1
X_1221_ dual_watchdog_inst.watchdog_fc.falling_edge_timeout.internal_count\[25\] dual_watchdog_inst.watchdog_fc.falling_edge_timeout.internal_count\[24\]
+ _0866_ dual_watchdog_inst.watchdog_fc.falling_edge_timeout.internal_count\[26\]
+ VGND VGND VPWR VPWR _0869_ sky130_fd_sc_hd__a31o_1
X_1083_ dual_watchdog_inst.watchdog_fc.rising_edge_timeout.assert_time\[15\] net66
+ _0745_ _0773_ _0764_ VGND VGND VPWR VPWR _0242_ sky130_fd_sc_hd__a311oi_1
X_1152_ _0822_ _0823_ VGND VGND VPWR VPWR _0022_ sky130_fd_sc_hd__nor2_1
XFILLER_0_59_177 VGND VGND VPWR VPWR sky130_fd_sc_hd__decap_3
XFILLER_0_55_361 VGND VGND VPWR VPWR sky130_fd_sc_hd__fill_1
X_1985_ _0686_ VGND VGND VPWR VPWR _0687_ sky130_fd_sc_hd__inv_2
XFILLER_0_23_51 VGND VGND VPWR VPWR sky130_fd_sc_hd__decap_4
XFILLER_0_30_228 VGND VGND VPWR VPWR sky130_fd_sc_hd__fill_1
XFILLER_0_2_141 VGND VGND VPWR VPWR sky130_fd_sc_hd__fill_1
XFILLER_0_54_3 VPWR VGND VPWR VGND sky130_ef_sc_hd__decap_12
X_1419_ _1009_ _0325_ VGND VGND VPWR VPWR _0132_ sky130_fd_sc_hd__nor2_1
XFILLER_0_60_27 VGND VGND VPWR VPWR sky130_fd_sc_hd__fill_1
X_1770_ _0561_ VGND VGND VPWR VPWR _0077_ sky130_fd_sc_hd__inv_2
X_2253_ clknet_leaf_5_clk _0037_ _0100_ VGND VGND VPWR VPWR dual_watchdog_inst.watchdog_fc.rising_edge_timeout.internal_count\[16\]
+ sky130_fd_sc_hd__dfrtp_1
X_2184_ clknet_leaf_10_clk _0264_ VGND VGND VPWR VPWR uart_tx_jetson_inst.data_reg\[7\]
+ sky130_fd_sc_hd__dfxtp_1
XFILLER_0_18_73 VGND VGND VPWR VPWR sky130_fd_sc_hd__fill_1
X_1204_ dual_watchdog_inst.watchdog_fc.falling_edge_timeout.internal_count\[21\] dual_watchdog_inst.watchdog_fc.falling_edge_timeout.internal_count\[20\]
+ VGND VGND VPWR VPWR _0857_ sky130_fd_sc_hd__nand2_1
X_1066_ dual_watchdog_inst.watchdog_fc.rising_edge_timeout.assert_time\[20\] _0754_
+ dual_watchdog_inst.watchdog_fc.rising_edge_timeout.assert_time\[21\] VGND VGND VPWR
+ VPWR _0763_ sky130_fd_sc_hd__a21oi_1
X_1135_ dual_watchdog_inst.watchdog_fc.falling_edge_timeout.assert_time\[25\] dual_watchdog_inst.watchdog_fc.falling_edge_timeout.assert_time\[24\]
+ dual_watchdog_inst.watchdog_fc.falling_edge_timeout.assert_time\[26\] VGND VGND
+ VPWR VPWR _0810_ sky130_fd_sc_hd__or3_1
X_1899_ _0638_ VGND VGND VPWR VPWR _0094_ sky130_fd_sc_hd__inv_2
XFILLER_0_47_169 VGND VGND VPWR VPWR sky130_fd_sc_hd__fill_1
XFILLER_0_28_361 VGND VGND VPWR VPWR sky130_fd_sc_hd__fill_1
XFILLER_0_7_266 VGND VGND VPWR VPWR sky130_fd_sc_hd__decap_3
X_1968_ _0675_ VGND VGND VPWR VPWR _0676_ sky130_fd_sc_hd__clkbuf_2
XFILLER_0_26_309 VGND VGND VPWR VPWR sky130_fd_sc_hd__decap_4
XFILLER_0_39_39 VGND VGND VPWR VPWR sky130_fd_sc_hd__decap_4
XFILLER_0_55_38 VGND VGND VPWR VPWR sky130_fd_sc_hd__decap_8
Xhold5 rst_cnt\[0\] VGND VGND VPWR VPWR net19 sky130_fd_sc_hd__dlygate4sd3_1
XTAP_209 VGND VPWR sky130_fd_sc_hd__tapvpwrvgnd_1
XFILLER_0_44_106 VGND VGND VPWR VPWR sky130_fd_sc_hd__fill_1
XFILLER_0_37_191 VGND VGND VPWR VPWR sky130_fd_sc_hd__decap_3
X_1822_ uart_tx_raspi_inst.prescale_reg\[2\] uart_tx_raspi_inst.prescale_reg\[1\]
+ uart_tx_raspi_inst.prescale_reg\[0\] VGND VGND VPWR VPWR _0593_ sky130_fd_sc_hd__or3_1
XFILLER_0_29_169 VGND VGND VPWR VPWR sky130_fd_sc_hd__fill_1
XFILLER_0_4_258 VGND VGND VPWR VPWR sky130_fd_sc_hd__decap_6
XFILLER_0_4_247 VGND VGND VPWR VPWR sky130_fd_sc_hd__decap_4
X_1753_ _0559_ VGND VGND VPWR VPWR _0062_ sky130_fd_sc_hd__inv_2
X_1684_ uart_rx_jetson_inst.bit_cnt\[3\] _0506_ _0499_ _0515_ VGND VGND VPWR VPWR
+ _0516_ sky130_fd_sc_hd__o2bb2a_1
XFILLER_0_20_74 VGND VGND VPWR VPWR sky130_fd_sc_hd__decap_4
XFILLER_0_20_85 VGND VGND VPWR VPWR sky130_fd_sc_hd__fill_1
XFILLER_0_45_82 VGND VGND VPWR VPWR sky130_fd_sc_hd__fill_1
X_2167_ clknet_leaf_2_clk _0247_ _0077_ VGND VGND VPWR VPWR dual_watchdog_inst.watchdog_fc.rising_edge_timeout.assert_time\[20\]
+ sky130_fd_sc_hd__dfrtp_4
XFILLER_0_29_94 VGND VGND VPWR VPWR sky130_fd_sc_hd__decap_3
XFILLER_0_17_3 VGND VGND VPWR VPWR sky130_fd_sc_hd__decap_6
X_2236_ clknet_leaf_29_clk _0002_ net8 VGND VGND VPWR VPWR dual_watchdog_inst.watchdog_fc.falling_edge_timeout.tcnt
+ sky130_fd_sc_hd__dfrtp_1
X_1049_ dual_watchdog_inst.watchdog_fc.rising_edge_timeout.assert_time\[26\] _0748_
+ _0749_ _0750_ VGND VGND VPWR VPWR _0751_ sky130_fd_sc_hd__nand4_1
XFILLER_0_35_117 VPWR VGND VPWR VGND sky130_ef_sc_hd__decap_12
XFILLER_0_35_106 VGND VGND VPWR VPWR sky130_fd_sc_hd__decap_6
X_2098_ clknet_leaf_16_clk net74 VGND VGND VPWR VPWR uart_tx_jetson_inst.bit_cnt\[2\]
+ sky130_fd_sc_hd__dfxtp_1
X_1118_ _0759_ _0795_ VGND VGND VPWR VPWR _0229_ sky130_fd_sc_hd__nor2_1
XFILLER_0_43_172 VGND VGND VPWR VPWR sky130_fd_sc_hd__fill_2
XFILLER_0_31_345 VGND VGND VPWR VPWR sky130_fd_sc_hd__fill_1
XFILLER_0_31_323 VGND VGND VPWR VPWR sky130_fd_sc_hd__decap_4
XFILLER_0_34_161 VGND VGND VPWR VPWR sky130_fd_sc_hd__decap_6
XFILLER_0_26_128 VGND VGND VPWR VPWR sky130_fd_sc_hd__fill_2
XFILLER_0_22_323 VGND VGND VPWR VPWR sky130_fd_sc_hd__fill_2
X_2021_ _0711_ net195 _0703_ VGND VGND VPWR VPWR _0712_ sky130_fd_sc_hd__mux2_1
XFILLER_0_57_231 VPWR VGND VPWR VGND sky130_ef_sc_hd__decap_12
XFILLER_0_15_96 VPWR VGND VPWR VGND sky130_ef_sc_hd__decap_12
X_1805_ _0581_ net141 _0571_ VGND VGND VPWR VPWR _0582_ sky130_fd_sc_hd__mux2_1
Xhold224 _0280_ VGND VGND VPWR VPWR net238 sky130_fd_sc_hd__dlygate4sd3_1
XFILLER_0_31_73 VGND VGND VPWR VPWR sky130_fd_sc_hd__fill_1
Xhold213 uart_rx_raspi_inst.prescale_reg\[13\] VGND VGND VPWR VPWR net227 sky130_fd_sc_hd__dlygate4sd3_1
Xhold202 dual_watchdog_inst.watchdog_fc.falling_edge_timeout.assert_time\[6\] VGND
+ VGND VPWR VPWR net216 sky130_fd_sc_hd__dlygate4sd3_1
XFILLER_0_13_334 VGND VGND VPWR VPWR sky130_fd_sc_hd__fill_2
X_1736_ _0536_ _0552_ VGND VGND VPWR VPWR _0222_ sky130_fd_sc_hd__nor2_1
XFILLER_0_17_139 VGND VGND VPWR VPWR sky130_fd_sc_hd__decap_4
XFILLER_0_40_175 VGND VGND VPWR VPWR sky130_fd_sc_hd__fill_1
X_1598_ net23 _0927_ _0450_ VGND VGND VPWR VPWR _0186_ sky130_fd_sc_hd__o21a_1
X_1667_ _0499_ _0501_ VGND VGND VPWR VPWR _0502_ sky130_fd_sc_hd__nand2b_1
X_2219_ clknet_leaf_26_clk _0004_ net11 VGND VGND VPWR VPWR dual_watchdog_inst.watchdog_fc.falling_edge_timeout.internal_count\[10\]
+ sky130_fd_sc_hd__dfrtp_1
XFILLER_0_48_253 VGND VGND VPWR VPWR sky130_fd_sc_hd__decap_6
XFILLER_0_8_361 VGND VGND VPWR VPWR sky130_fd_sc_hd__fill_1
XFILLER_0_6_3 VPWR VGND VPWR VGND sky130_ef_sc_hd__decap_12
XFILLER_0_36_29 VGND VGND VPWR VPWR sky130_fd_sc_hd__decap_4
XFILLER_0_6_309 VGND VGND VPWR VPWR sky130_fd_sc_hd__fill_2
XFILLER_0_22_131 VGND VGND VPWR VPWR sky130_fd_sc_hd__decap_8
XFILLER_0_22_153 VGND VGND VPWR VPWR sky130_fd_sc_hd__fill_1
X_1383_ _0986_ _0987_ VGND VGND VPWR VPWR _0988_ sky130_fd_sc_hd__and2b_1
X_1521_ net225 _0396_ VGND VGND VPWR VPWR _0400_ sky130_fd_sc_hd__nand2_1
X_1452_ net49 _0346_ VGND VGND VPWR VPWR _0350_ sky130_fd_sc_hd__nand2_1
XFILLER_0_22_197 VGND VGND VPWR VPWR sky130_fd_sc_hd__fill_1
X_2004_ _0808_ _0699_ _0700_ VGND VGND VPWR VPWR _0701_ sky130_fd_sc_hd__and3_1
XFILLER_0_45_234 VPWR VGND VPWR VGND sky130_ef_sc_hd__decap_12
XFILLER_0_42_83 VGND VGND VPWR VPWR sky130_fd_sc_hd__fill_1
XFILLER_0_60_237 VPWR VGND VPWR VGND sky130_ef_sc_hd__decap_12
X_1719_ _0540_ _0541_ _0536_ VGND VGND VPWR VPWR _0216_ sky130_fd_sc_hd__a21oi_1
XFILLER_0_13_186 VGND VGND VPWR VPWR sky130_fd_sc_hd__decap_3
XTAP_392 VGND VPWR sky130_fd_sc_hd__tapvpwrvgnd_1
XTAP_381 VGND VPWR sky130_fd_sc_hd__tapvpwrvgnd_1
XTAP_370 VGND VPWR sky130_fd_sc_hd__tapvpwrvgnd_1
XPHY_98 VGND VGND VPWR VPWR sky130_fd_sc_hd__decap_3
XPHY_87 VGND VGND VPWR VPWR sky130_fd_sc_hd__decap_3
XPHY_76 VGND VGND VPWR VPWR sky130_fd_sc_hd__decap_3
XPHY_65 VGND VGND VPWR VPWR sky130_fd_sc_hd__decap_3
XPHY_54 VGND VGND VPWR VPWR sky130_fd_sc_hd__decap_3
XPHY_10 VGND VGND VPWR VPWR sky130_fd_sc_hd__decap_3
XPHY_21 VGND VGND VPWR VPWR sky130_fd_sc_hd__decap_3
XPHY_32 VGND VGND VPWR VPWR sky130_fd_sc_hd__decap_3
XPHY_43 VGND VGND VPWR VPWR sky130_fd_sc_hd__decap_3
XFILLER_0_59_337 VPWR VGND VPWR VGND sky130_ef_sc_hd__decap_12
XFILLER_0_12_42 VGND VGND VPWR VPWR sky130_fd_sc_hd__fill_2
XFILLER_0_42_237 VGND VGND VPWR VPWR sky130_fd_sc_hd__decap_8
X_1504_ _1008_ net3 VGND VGND VPWR VPWR _0387_ sky130_fd_sc_hd__or2_1
XFILLER_0_2_345 VPWR VGND VPWR VGND sky130_ef_sc_hd__decap_12
XFILLER_0_2_301 VGND VGND VPWR VPWR sky130_fd_sc_hd__decap_6
XFILLER_0_10_123 VGND VGND VPWR VPWR sky130_fd_sc_hd__decap_6
XFILLER_0_12_64 VGND VGND VPWR VPWR sky130_fd_sc_hd__decap_8
X_1366_ uart_rx_raspi_inst.rxd_reg _0974_ VGND VGND VPWR VPWR _0975_ sky130_fd_sc_hd__and2_1
X_1435_ uart_rx_raspi_inst.prescale_reg\[4\] net30 VGND VGND VPWR VPWR _0337_ sky130_fd_sc_hd__or2_1
XFILLER_0_10_145 VPWR VGND VPWR VGND sky130_ef_sc_hd__decap_12
X_1297_ dual_watchdog_inst.watchdog_fc.rising_edge_timeout.internal_count\[24\] _0919_
+ _0764_ VGND VGND VPWR VPWR _0920_ sky130_fd_sc_hd__a21oi_1
XFILLER_0_33_237 VGND VGND VPWR VPWR sky130_fd_sc_hd__fill_2
XFILLER_0_5_150 VGND VGND VPWR VPWR sky130_fd_sc_hd__decap_6
XFILLER_0_41_281 VGND VGND VPWR VPWR sky130_fd_sc_hd__decap_3
XFILLER_0_56_307 VGND VGND VPWR VPWR sky130_fd_sc_hd__fill_1
XFILLER_0_58_27 VGND VGND VPWR VPWR sky130_fd_sc_hd__fill_1
X_1151_ net96 net62 net103 VGND VGND VPWR VPWR _0823_ sky130_fd_sc_hd__a21oi_1
X_1220_ net143 dual_watchdog_inst.watchdog_fc.falling_edge_timeout.internal_count\[24\]
+ _0866_ _0868_ _0820_ VGND VGND VPWR VPWR _0020_ sky130_fd_sc_hd__a311oi_1
X_1082_ dual_watchdog_inst.watchdog_fc.rising_edge_timeout.assert_time\[14\] _0745_
+ dual_watchdog_inst.watchdog_fc.rising_edge_timeout.assert_time\[15\] VGND VGND VPWR
+ VPWR _0773_ sky130_fd_sc_hd__a21oi_1
X_1984_ dual_watchdog_inst.watchdog_fc.falling_edge_timeout.assert_time\[21\] dual_watchdog_inst.watchdog_fc.falling_edge_timeout.assert_time\[20\]
+ _0682_ VGND VGND VPWR VPWR _0686_ sky130_fd_sc_hd__and3_1
XFILLER_0_2_197 VPWR VGND VPWR VGND sky130_ef_sc_hd__decap_12
XFILLER_0_48_93 VGND VGND VPWR VPWR sky130_fd_sc_hd__fill_2
X_1418_ uart_rx_raspi_inst.bit_cnt\[3\] _0972_ _0998_ _0324_ VGND VGND VPWR VPWR _0325_
+ sky130_fd_sc_hd__o2bb2a_1
XFILLER_0_3_51 VGND VGND VPWR VPWR sky130_fd_sc_hd__decap_4
X_1349_ _0959_ net145 _0945_ VGND VGND VPWR VPWR _0960_ sky130_fd_sc_hd__mux2_1
XFILLER_0_38_329 VGND VGND VPWR VPWR sky130_fd_sc_hd__decap_4
XFILLER_0_56_104 VGND VGND VPWR VPWR sky130_fd_sc_hd__fill_1
XFILLER_0_20_251 VGND VGND VPWR VPWR sky130_fd_sc_hd__fill_1
X_2252_ clknet_leaf_5_clk _0036_ _0099_ VGND VGND VPWR VPWR dual_watchdog_inst.watchdog_fc.rising_edge_timeout.internal_count\[15\]
+ sky130_fd_sc_hd__dfrtp_1
X_2183_ clknet_leaf_10_clk _0263_ VGND VGND VPWR VPWR uart_tx_jetson_inst.data_reg\[6\]
+ sky130_fd_sc_hd__dfxtp_1
XFILLER_0_33_9 VGND VGND VPWR VPWR sky130_fd_sc_hd__fill_1
X_1134_ _0808_ VGND VGND VPWR VPWR _0809_ sky130_fd_sc_hd__inv_2
X_1203_ net234 _0855_ _0856_ VGND VGND VPWR VPWR _0015_ sky130_fd_sc_hd__o21ba_1
X_1065_ _0759_ _0761_ _0762_ VGND VGND VPWR VPWR _0249_ sky130_fd_sc_hd__nor3b_1
X_1898_ _0638_ VGND VGND VPWR VPWR _0093_ sky130_fd_sc_hd__inv_2
XFILLER_0_7_245 VGND VGND VPWR VPWR sky130_fd_sc_hd__decap_8
X_1967_ dual_watchdog_inst.watchdog_fc.falling_edge_timeout.assert_time\[15\] dual_watchdog_inst.watchdog_fc.falling_edge_timeout.assert_time\[14\]
+ _0666_ _0669_ VGND VGND VPWR VPWR _0675_ sky130_fd_sc_hd__and4_1
XFILLER_0_59_70 VGND VGND VPWR VPWR sky130_fd_sc_hd__fill_2
XFILLER_0_11_262 VPWR VGND VPWR VGND sky130_ef_sc_hd__decap_12
XFILLER_0_38_148 VPWR VGND VPWR VGND sky130_ef_sc_hd__decap_12
XFILLER_0_38_137 VGND VGND VPWR VPWR sky130_fd_sc_hd__decap_3
Xhold6 _0180_ VGND VGND VPWR VPWR net20 sky130_fd_sc_hd__dlygate4sd3_1
XFILLER_0_29_104 VGND VGND VPWR VPWR sky130_fd_sc_hd__fill_1
Xclkbuf_leaf_10_clk clknet_2_3__leaf_clk VGND VGND VPWR VPWR clknet_leaf_10_clk sky130_fd_sc_hd__clkbuf_16
XFILLER_0_40_302 VGND VGND VPWR VPWR sky130_fd_sc_hd__fill_2
X_1821_ net16 _0590_ _0592_ VGND VGND VPWR VPWR _0267_ sky130_fd_sc_hd__a21oi_1
X_1752_ _0559_ VGND VGND VPWR VPWR _0061_ sky130_fd_sc_hd__inv_2
X_1683_ uart_rx_jetson_inst.bit_cnt\[3\] _0510_ _0500_ uart_rx_jetson_inst.rxd_reg
+ VGND VGND VPWR VPWR _0515_ sky130_fd_sc_hd__o2bb2a_1
X_2166_ clknet_leaf_2_clk _0246_ _0076_ VGND VGND VPWR VPWR dual_watchdog_inst.watchdog_fc.rising_edge_timeout.assert_time\[19\]
+ sky130_fd_sc_hd__dfrtp_1
X_2097_ clknet_leaf_16_clk _0177_ VGND VGND VPWR VPWR uart_tx_jetson_inst.bit_cnt\[1\]
+ sky130_fd_sc_hd__dfxtp_1
X_1117_ dual_watchdog_inst.watchdog_fc.rising_edge_timeout.assert_time\[2\] _0794_
+ VGND VGND VPWR VPWR _0795_ sky130_fd_sc_hd__xor2_1
X_2235_ clknet_leaf_0_clk _0021_ net12 VGND VGND VPWR VPWR dual_watchdog_inst.watchdog_fc.falling_edge_timeout.internal_count\[26\]
+ sky130_fd_sc_hd__dfrtp_1
X_1048_ dual_watchdog_inst.watchdog_fc.rising_edge_timeout.assert_time\[25\] dual_watchdog_inst.watchdog_fc.rising_edge_timeout.assert_time\[24\]
+ VGND VGND VPWR VPWR _0750_ sky130_fd_sc_hd__and2_1
XFILLER_0_35_129 VPWR VGND VPWR VGND sky130_ef_sc_hd__decap_12
XFILLER_0_0_41 VPWR VGND VPWR VGND sky130_ef_sc_hd__decap_12
XFILLER_0_0_85 VPWR VGND VPWR VGND sky130_ef_sc_hd__decap_12
XFILLER_0_16_332 VGND VGND VPWR VPWR sky130_fd_sc_hd__fill_1
XFILLER_0_31_357 VGND VGND VPWR VPWR sky130_fd_sc_hd__decap_4
XFILLER_0_3_281 VPWR VGND VPWR VGND sky130_ef_sc_hd__decap_12
XFILLER_0_16_354 VGND VGND VPWR VPWR sky130_fd_sc_hd__decap_8
XFILLER_0_19_192 VGND VGND VPWR VPWR sky130_fd_sc_hd__decap_4
X_2020_ uart_rx_jetson_inst.data_reg\[5\] _0501_ VGND VGND VPWR VPWR _0711_ sky130_fd_sc_hd__and2_1
XFILLER_0_57_243 VPWR VGND VPWR VGND sky130_ef_sc_hd__decap_12
XFILLER_0_9_307 VGND VGND VPWR VPWR sky130_fd_sc_hd__decap_3
Xhold203 dual_watchdog_inst.watchdog_fc.rising_edge_timeout.internal_count\[15\] VGND
+ VGND VPWR VPWR net217 sky130_fd_sc_hd__dlygate4sd3_1
X_1804_ uart_rx_raspi_inst.m_axis_tdata_reg\[5\] uart_tx_jetson_inst.data_reg\[6\]
+ _0383_ VGND VGND VPWR VPWR _0581_ sky130_fd_sc_hd__mux2_1
XFILLER_0_31_63 VGND VGND VPWR VPWR sky130_fd_sc_hd__fill_1
Xhold214 uart_tx_raspi_inst.prescale_reg\[6\] VGND VGND VPWR VPWR net228 sky130_fd_sc_hd__dlygate4sd3_1
X_1666_ _0500_ VGND VGND VPWR VPWR _0501_ sky130_fd_sc_hd__buf_2
X_1735_ net82 _0550_ VGND VGND VPWR VPWR _0552_ sky130_fd_sc_hd__xnor2_1
X_1597_ rst_cnt\[7\] _0928_ VGND VGND VPWR VPWR _0450_ sky130_fd_sc_hd__or2b_1
X_2149_ clknet_leaf_30_clk _0229_ _0059_ VGND VGND VPWR VPWR dual_watchdog_inst.watchdog_fc.rising_edge_timeout.assert_time\[2\]
+ sky130_fd_sc_hd__dfstp_1
X_2218_ clknet_leaf_26_clk _0029_ net11 VGND VGND VPWR VPWR dual_watchdog_inst.watchdog_fc.falling_edge_timeout.internal_count\[9\]
+ sky130_fd_sc_hd__dfrtp_1
XFILLER_0_48_298 VGND VGND VPWR VPWR sky130_fd_sc_hd__fill_1
XFILLER_0_16_173 VGND VGND VPWR VPWR sky130_fd_sc_hd__fill_1
XFILLER_0_31_165 VGND VGND VPWR VPWR sky130_fd_sc_hd__decap_3
XFILLER_0_39_254 VPWR VGND VPWR VGND sky130_ef_sc_hd__decap_12
XFILLER_0_54_279 VGND VGND VPWR VPWR sky130_fd_sc_hd__fill_2
X_1520_ _0389_ _0398_ _0399_ VGND VGND VPWR VPWR _0159_ sky130_fd_sc_hd__a21oi_1
XFILLER_0_10_305 VGND VGND VPWR VPWR sky130_fd_sc_hd__decap_3
X_1382_ uart_rx_raspi_inst.data_reg\[4\] uart_rx_raspi_inst.m_axis_tdata_reg\[4\]
+ _0977_ VGND VGND VPWR VPWR _0987_ sky130_fd_sc_hd__mux2_1
X_1451_ _0348_ VGND VGND VPWR VPWR _0349_ sky130_fd_sc_hd__buf_2
X_2003_ dual_watchdog_inst.watchdog_fc.falling_edge_timeout.assert_time\[25\] dual_watchdog_inst.watchdog_fc.falling_edge_timeout.assert_time\[24\]
+ dual_watchdog_inst.watchdog_fc.falling_edge_timeout.assert_time\[26\] _0694_ VGND
+ VGND VPWR VPWR _0700_ sky130_fd_sc_hd__nand4_1
XFILLER_0_45_246 VGND VGND VPWR VPWR sky130_fd_sc_hd__decap_6
XFILLER_0_45_213 VGND VGND VPWR VPWR sky130_fd_sc_hd__decap_8
XFILLER_0_60_249 VGND VGND VPWR VPWR sky130_fd_sc_hd__decap_3
XFILLER_0_6_62 VGND VGND VPWR VPWR sky130_fd_sc_hd__fill_1
X_1718_ net36 _0537_ VGND VGND VPWR VPWR _0541_ sky130_fd_sc_hd__nand2_1
XFILLER_0_13_110 VGND VGND VPWR VPWR sky130_fd_sc_hd__fill_2
XFILLER_0_13_165 VGND VGND VPWR VPWR sky130_fd_sc_hd__decap_3
X_1649_ uart_rx_jetson_inst.m_axis_tdata_reg\[4\] uart_rx_jetson_inst.data_reg\[4\]
+ _0479_ VGND VGND VPWR VPWR _0488_ sky130_fd_sc_hd__mux2_1
XTAP_393 VGND VPWR sky130_fd_sc_hd__tapvpwrvgnd_1
XTAP_382 VGND VPWR sky130_fd_sc_hd__tapvpwrvgnd_1
XTAP_371 VGND VPWR sky130_fd_sc_hd__tapvpwrvgnd_1
XTAP_360 VGND VPWR sky130_fd_sc_hd__tapvpwrvgnd_1
XPHY_99 VGND VGND VPWR VPWR sky130_fd_sc_hd__decap_3
XPHY_88 VGND VGND VPWR VPWR sky130_fd_sc_hd__decap_3
XPHY_77 VGND VGND VPWR VPWR sky130_fd_sc_hd__decap_3
XPHY_66 VGND VGND VPWR VPWR sky130_fd_sc_hd__decap_3
XPHY_55 VGND VGND VPWR VPWR sky130_fd_sc_hd__decap_3
XPHY_11 VGND VGND VPWR VPWR sky130_fd_sc_hd__decap_3
XPHY_22 VGND VGND VPWR VPWR sky130_fd_sc_hd__decap_3
XPHY_33 VGND VGND VPWR VPWR sky130_fd_sc_hd__decap_3
XPHY_44 VGND VGND VPWR VPWR sky130_fd_sc_hd__decap_3
XFILLER_0_59_349 VPWR VGND VPWR VGND sky130_ef_sc_hd__decap_12
XFILLER_0_59_305 VPWR VGND VPWR VGND sky130_ef_sc_hd__decap_12
X_1503_ _0386_ VGND VGND VPWR VPWR _0155_ sky130_fd_sc_hd__clkbuf_1
XFILLER_0_2_357 VGND VGND VPWR VPWR sky130_fd_sc_hd__decap_4
XFILLER_0_10_157 VPWR VGND VPWR VGND sky130_ef_sc_hd__decap_12
X_1296_ _0916_ _0914_ _0919_ VGND VGND VPWR VPWR _0045_ sky130_fd_sc_hd__a21oi_1
X_1365_ uart_rx_raspi_inst.bit_cnt\[0\] _0973_ VGND VGND VPWR VPWR _0974_ sky130_fd_sc_hd__or2_2
X_1434_ _0998_ _0336_ _0328_ VGND VGND VPWR VPWR _0136_ sky130_fd_sc_hd__a21oi_1
XTAP_190 VGND VPWR sky130_fd_sc_hd__tapvpwrvgnd_1
X_1150_ dual_watchdog_inst.watchdog_fc.falling_edge_timeout.internal_count\[1\] dual_watchdog_inst.watchdog_fc.falling_edge_timeout.internal_count\[0\]
+ dual_watchdog_inst.watchdog_fc.falling_edge_timeout.internal_count\[2\] VGND VGND
+ VPWR VPWR _0822_ sky130_fd_sc_hd__and3_1
X_1081_ _0772_ VGND VGND VPWR VPWR _0243_ sky130_fd_sc_hd__clkbuf_1
X_1983_ net190 _0682_ _0685_ _0841_ VGND VGND VPWR VPWR _0309_ sky130_fd_sc_hd__o211a_1
X_1417_ uart_rx_raspi_inst.bit_cnt\[3\] _1011_ _0974_ uart_rx_raspi_inst.rxd_reg VGND
+ VGND VPWR VPWR _0324_ sky130_fd_sc_hd__o2bb2a_1
XFILLER_0_2_176 VPWR VGND VPWR VGND sky130_ef_sc_hd__decap_12
X_1279_ dual_watchdog_inst.watchdog_fc.rising_edge_timeout.internal_count\[19\] _0906_
+ VGND VGND VPWR VPWR _0907_ sky130_fd_sc_hd__nor2_1
X_1348_ uart_rx_jetson_inst.m_axis_tdata_reg\[7\] uart_tx_raspi_inst.data_reg\[8\]
+ _0930_ VGND VGND VPWR VPWR _0959_ sky130_fd_sc_hd__mux2_1
XFILLER_0_46_330 VPWR VGND VPWR VGND sky130_ef_sc_hd__decap_12
XFILLER_0_14_282 VGND VGND VPWR VPWR sky130_fd_sc_hd__decap_8
XFILLER_0_56_138 VGND VGND VPWR VPWR sky130_fd_sc_hd__fill_2
XFILLER_0_60_29 VPWR VGND VPWR VGND sky130_ef_sc_hd__decap_12
XFILLER_0_52_355 VGND VGND VPWR VPWR sky130_fd_sc_hd__decap_6
XFILLER_0_49_190 VGND VGND VPWR VPWR sky130_fd_sc_hd__decap_6
X_2251_ clknet_leaf_5_clk _0035_ _0098_ VGND VGND VPWR VPWR dual_watchdog_inst.watchdog_fc.rising_edge_timeout.internal_count\[14\]
+ sky130_fd_sc_hd__dfrtp_1
XFILLER_0_20_230 VGND VGND VPWR VPWR sky130_fd_sc_hd__fill_1
X_2182_ clknet_leaf_11_clk _0262_ VGND VGND VPWR VPWR uart_tx_jetson_inst.data_reg\[5\]
+ sky130_fd_sc_hd__dfxtp_1
X_1064_ dual_watchdog_inst.watchdog_fc.rising_edge_timeout.assert_time\[21\] dual_watchdog_inst.watchdog_fc.rising_edge_timeout.assert_time\[20\]
+ _0754_ dual_watchdog_inst.watchdog_fc.rising_edge_timeout.assert_time\[22\] VGND
+ VGND VPWR VPWR _0762_ sky130_fd_sc_hd__a31o_1
XFILLER_0_26_9 VPWR VGND VPWR VGND sky130_ef_sc_hd__decap_12
X_1133_ _0802_ _0805_ _0806_ _0807_ VGND VGND VPWR VPWR _0808_ sky130_fd_sc_hd__or4_2
X_1202_ dual_watchdog_inst.watchdog_fc.falling_edge_timeout.internal_count\[19\] dual_watchdog_inst.watchdog_fc.falling_edge_timeout.internal_count\[18\]
+ dual_watchdog_inst.watchdog_fc.falling_edge_timeout.internal_count\[20\] _0853_
+ _0820_ VGND VGND VPWR VPWR _0856_ sky130_fd_sc_hd__a41o_1
XFILLER_0_34_85 VGND VGND VPWR VPWR sky130_fd_sc_hd__decap_4
X_1966_ net134 VGND VGND VPWR VPWR _0674_ sky130_fd_sc_hd__inv_2
X_1897_ _0638_ VGND VGND VPWR VPWR _0092_ sky130_fd_sc_hd__inv_2
XFILLER_0_43_322 VGND VGND VPWR VPWR sky130_fd_sc_hd__decap_4
XFILLER_0_11_274 VGND VGND VPWR VPWR sky130_fd_sc_hd__decap_6
XFILLER_0_38_127 VGND VGND VPWR VPWR sky130_fd_sc_hd__fill_2
XFILLER_0_38_116 VGND VGND VPWR VPWR sky130_fd_sc_hd__fill_1
XFILLER_0_46_193 VGND VGND VPWR VPWR sky130_fd_sc_hd__decap_3
XFILLER_0_19_352 VGND VGND VPWR VPWR sky130_fd_sc_hd__decap_4
Xhold7 rst_cnt\[2\] VGND VGND VPWR VPWR net21 sky130_fd_sc_hd__dlygate4sd3_1
X_1820_ net16 _0590_ _1008_ VGND VGND VPWR VPWR _0592_ sky130_fd_sc_hd__o21bai_1
XFILLER_0_52_141 VPWR VGND VPWR VGND sky130_ef_sc_hd__decap_12
XFILLER_0_37_182 VGND VGND VPWR VPWR sky130_fd_sc_hd__decap_3
X_1751_ _0559_ VGND VGND VPWR VPWR _0060_ sky130_fd_sc_hd__inv_2
X_1682_ _1009_ _0514_ VGND VGND VPWR VPWR _0206_ sky130_fd_sc_hd__nor2_1
X_2234_ clknet_leaf_0_clk net144 net12 VGND VGND VPWR VPWR dual_watchdog_inst.watchdog_fc.falling_edge_timeout.internal_count\[25\]
+ sky130_fd_sc_hd__dfrtp_1
X_2096_ clknet_leaf_9_clk _0176_ VGND VGND VPWR VPWR uart_tx_jetson_inst.bit_cnt\[0\]
+ sky130_fd_sc_hd__dfxtp_1
X_1047_ dual_watchdog_inst.watchdog_fc.rising_edge_timeout.assert_time\[23\] dual_watchdog_inst.watchdog_fc.rising_edge_timeout.assert_time\[22\]
+ dual_watchdog_inst.watchdog_fc.rising_edge_timeout.assert_time\[21\] dual_watchdog_inst.watchdog_fc.rising_edge_timeout.assert_time\[20\]
+ VGND VGND VPWR VPWR _0749_ sky130_fd_sc_hd__and4_1
X_2165_ clknet_leaf_2_clk net99 _0075_ VGND VGND VPWR VPWR dual_watchdog_inst.watchdog_fc.rising_edge_timeout.assert_time\[18\]
+ sky130_fd_sc_hd__dfrtp_1
X_1116_ dual_watchdog_inst.watchdog_fc.rising_edge_timeout.assert_time\[1\] dual_watchdog_inst.watchdog_fc.rising_edge_timeout.assert_time\[0\]
+ VGND VGND VPWR VPWR _0794_ sky130_fd_sc_hd__nand2_1
X_1949_ _0660_ _0658_ _0662_ _0821_ VGND VGND VPWR VPWR _0298_ sky130_fd_sc_hd__a211oi_1
XFILLER_0_0_53 VGND VGND VPWR VPWR sky130_fd_sc_hd__decap_3
XFILLER_0_0_97 VPWR VGND VPWR VGND sky130_ef_sc_hd__decap_12
XFILLER_0_3_293 VPWR VGND VPWR VGND sky130_ef_sc_hd__decap_12
XFILLER_0_34_141 VGND VGND VPWR VPWR sky130_fd_sc_hd__fill_2
XFILLER_0_15_54 VGND VGND VPWR VPWR sky130_fd_sc_hd__fill_2
XFILLER_0_57_277 VGND VGND VPWR VPWR sky130_fd_sc_hd__decap_3
XFILLER_0_57_255 VGND VGND VPWR VPWR sky130_fd_sc_hd__decap_4
X_1803_ _0580_ VGND VGND VPWR VPWR _0261_ sky130_fd_sc_hd__clkbuf_1
XFILLER_0_40_155 VGND VGND VPWR VPWR sky130_fd_sc_hd__fill_1
XFILLER_0_31_97 VGND VGND VPWR VPWR sky130_fd_sc_hd__fill_1
XFILLER_0_25_163 VGND VGND VPWR VPWR sky130_fd_sc_hd__fill_1
X_1596_ _0927_ net42 _0000_ VGND VGND VPWR VPWR _0185_ sky130_fd_sc_hd__o21ai_1
Xhold204 dual_watchdog_inst.watchdog_fc.falling_edge_timeout.assert_time\[18\] VGND
+ VGND VPWR VPWR net218 sky130_fd_sc_hd__dlygate4sd3_1
X_1665_ _0496_ _0476_ VGND VGND VPWR VPWR _0500_ sky130_fd_sc_hd__nand2_1
X_1734_ _0550_ _0551_ _0536_ VGND VGND VPWR VPWR _0221_ sky130_fd_sc_hd__o21ba_1
Xhold215 uart_rx_jetson_inst.bit_cnt\[0\] VGND VGND VPWR VPWR net229 sky130_fd_sc_hd__dlygate4sd3_1
XFILLER_0_56_83 VGND VGND VPWR VPWR sky130_fd_sc_hd__fill_1
X_2217_ clknet_leaf_26_clk _0028_ net11 VGND VGND VPWR VPWR dual_watchdog_inst.watchdog_fc.falling_edge_timeout.internal_count\[8\]
+ sky130_fd_sc_hd__dfrtp_1
XFILLER_0_22_3 VPWR VGND VPWR VGND sky130_ef_sc_hd__decap_12
XFILLER_0_48_266 VGND VGND VPWR VPWR sky130_fd_sc_hd__fill_1
X_2079_ clknet_leaf_16_clk _0159_ VGND VGND VPWR VPWR uart_tx_jetson_inst.prescale_reg\[2\]
+ sky130_fd_sc_hd__dfxtp_1
X_2148_ clknet_leaf_2_clk _0228_ _0058_ VGND VGND VPWR VPWR dual_watchdog_inst.watchdog_fc.rising_edge_timeout.assert_time\[1\]
+ sky130_fd_sc_hd__dfrtp_1
XFILLER_0_31_111 VGND VGND VPWR VPWR sky130_fd_sc_hd__fill_1
XFILLER_0_31_199 VGND VGND VPWR VPWR sky130_fd_sc_hd__decap_4
XFILLER_0_31_177 VGND VGND VPWR VPWR sky130_fd_sc_hd__fill_2
XFILLER_0_39_266 VGND VGND VPWR VPWR sky130_fd_sc_hd__decap_8
XFILLER_0_39_233 VGND VGND VPWR VPWR sky130_fd_sc_hd__fill_2
X_1450_ uart_rx_raspi_inst.prescale_reg\[8\] _0346_ VGND VGND VPWR VPWR _0348_ sky130_fd_sc_hd__or2_1
XFILLER_0_22_100 VGND VGND VPWR VPWR sky130_fd_sc_hd__fill_1
XFILLER_0_22_122 VGND VGND VPWR VPWR sky130_fd_sc_hd__decap_4
X_1381_ _0963_ VGND VGND VPWR VPWR _0986_ sky130_fd_sc_hd__buf_2
XFILLER_0_42_52 VPWR VGND VPWR VGND sky130_ef_sc_hd__decap_12
X_2002_ dual_watchdog_inst.watchdog_fc.falling_edge_timeout.assert_time\[25\] dual_watchdog_inst.watchdog_fc.falling_edge_timeout.assert_time\[24\]
+ _0694_ dual_watchdog_inst.watchdog_fc.falling_edge_timeout.assert_time\[26\] VGND
+ VGND VPWR VPWR _0699_ sky130_fd_sc_hd__a31o_1
XFILLER_0_13_133 VGND VGND VPWR VPWR sky130_fd_sc_hd__decap_4
XTAP_350 VGND VPWR sky130_fd_sc_hd__tapvpwrvgnd_1
X_1579_ _0438_ _0440_ _1009_ VGND VGND VPWR VPWR _0177_ sky130_fd_sc_hd__a21oi_1
XFILLER_0_6_85 VPWR VGND VPWR VGND sky130_ef_sc_hd__decap_12
X_1717_ _0539_ VGND VGND VPWR VPWR _0540_ sky130_fd_sc_hd__buf_2
X_1648_ _0487_ VGND VGND VPWR VPWR _0199_ sky130_fd_sc_hd__clkbuf_1
XTAP_394 VGND VPWR sky130_fd_sc_hd__tapvpwrvgnd_1
XTAP_383 VGND VPWR sky130_fd_sc_hd__tapvpwrvgnd_1
XTAP_372 VGND VPWR sky130_fd_sc_hd__tapvpwrvgnd_1
XTAP_361 VGND VPWR sky130_fd_sc_hd__tapvpwrvgnd_1
XPHY_12 VGND VGND VPWR VPWR sky130_fd_sc_hd__decap_3
XPHY_89 VGND VGND VPWR VPWR sky130_fd_sc_hd__decap_3
XPHY_78 VGND VGND VPWR VPWR sky130_fd_sc_hd__decap_3
XPHY_67 VGND VGND VPWR VPWR sky130_fd_sc_hd__decap_3
XPHY_56 VGND VGND VPWR VPWR sky130_fd_sc_hd__decap_3
XPHY_23 VGND VGND VPWR VPWR sky130_fd_sc_hd__decap_3
XPHY_34 VGND VGND VPWR VPWR sky130_fd_sc_hd__decap_3
XPHY_45 VGND VGND VPWR VPWR sky130_fd_sc_hd__decap_3
XFILLER_0_51_217 VGND VGND VPWR VPWR sky130_fd_sc_hd__decap_6
XFILLER_0_59_317 VPWR VGND VPWR VGND sky130_ef_sc_hd__decap_12
XFILLER_0_50_261 VGND VGND VPWR VPWR sky130_fd_sc_hd__fill_1
XFILLER_0_50_250 VGND VGND VPWR VPWR sky130_fd_sc_hd__fill_2
X_1502_ _0964_ _0379_ _0385_ VGND VGND VPWR VPWR _0386_ sky130_fd_sc_hd__and3b_1
X_1433_ _0965_ _0335_ _1001_ VGND VGND VPWR VPWR _0336_ sky130_fd_sc_hd__a21o_1
XFILLER_0_10_169 VGND VGND VPWR VPWR sky130_fd_sc_hd__fill_1
X_1295_ _0918_ VGND VGND VPWR VPWR _0919_ sky130_fd_sc_hd__clkbuf_2
X_1364_ uart_rx_raspi_inst.bit_cnt\[3\] uart_rx_raspi_inst.bit_cnt\[2\] uart_rx_raspi_inst.bit_cnt\[1\]
+ VGND VGND VPWR VPWR _0973_ sky130_fd_sc_hd__or3_1
XFILLER_0_58_361 VGND VGND VPWR VPWR sky130_fd_sc_hd__fill_1
XTAP_180 VGND VPWR sky130_fd_sc_hd__tapvpwrvgnd_1
XTAP_191 VGND VPWR sky130_fd_sc_hd__tapvpwrvgnd_1
XFILLER_0_56_309 VPWR VGND VPWR VGND sky130_ef_sc_hd__decap_12
XFILLER_0_49_361 VGND VGND VPWR VPWR sky130_fd_sc_hd__fill_1
XFILLER_0_24_217 VGND VGND VPWR VPWR sky130_fd_sc_hd__fill_1
XFILLER_0_58_29 VPWR VGND VPWR VGND sky130_ef_sc_hd__decap_12
XFILLER_0_32_294 VGND VGND VPWR VPWR sky130_fd_sc_hd__fill_1
XFILLER_0_32_250 VGND VGND VPWR VPWR sky130_fd_sc_hd__fill_2
X_1080_ _0747_ _0766_ _0771_ VGND VGND VPWR VPWR _0772_ sky130_fd_sc_hd__and3b_1
XFILLER_0_59_169 VGND VGND VPWR VPWR sky130_fd_sc_hd__decap_8
X_1982_ _0684_ VGND VGND VPWR VPWR _0685_ sky130_fd_sc_hd__inv_2
X_1416_ _1013_ _1014_ _1009_ VGND VGND VPWR VPWR _0131_ sky130_fd_sc_hd__a21oi_1
XFILLER_0_2_188 VGND VGND VPWR VPWR sky130_fd_sc_hd__decap_8
X_1347_ _0958_ VGND VGND VPWR VPWR _0118_ sky130_fd_sc_hd__clkbuf_1
X_1278_ _0905_ _0906_ VGND VGND VPWR VPWR _0039_ sky130_fd_sc_hd__nor2_1
XFILLER_0_46_342 VPWR VGND VPWR VGND sky130_ef_sc_hd__decap_12
XFILLER_0_14_261 VGND VGND VPWR VPWR sky130_fd_sc_hd__decap_4
XFILLER_0_52_323 VGND VGND VPWR VPWR sky130_fd_sc_hd__decap_4
XFILLER_0_12_209 VGND VGND VPWR VPWR sky130_fd_sc_hd__fill_1
X_2250_ clknet_leaf_5_clk _0034_ _0097_ VGND VGND VPWR VPWR dual_watchdog_inst.watchdog_fc.rising_edge_timeout.internal_count\[13\]
+ sky130_fd_sc_hd__dfrtp_1
X_1201_ _0854_ _0855_ VGND VGND VPWR VPWR _0013_ sky130_fd_sc_hd__nor2_1
X_2181_ clknet_leaf_11_clk _0261_ VGND VGND VPWR VPWR uart_tx_jetson_inst.data_reg\[4\]
+ sky130_fd_sc_hd__dfxtp_1
X_1063_ net117 _0761_ _0755_ _0738_ VGND VGND VPWR VPWR _0250_ sky130_fd_sc_hd__o211a_1
X_1132_ dual_watchdog_inst.watchdog_fc.falling_edge_timeout.internal_count\[3\] dual_watchdog_inst.watchdog_fc.falling_edge_timeout.internal_count\[2\]
+ dual_watchdog_inst.watchdog_fc.falling_edge_timeout.internal_count\[5\] dual_watchdog_inst.watchdog_fc.falling_edge_timeout.internal_count\[4\]
+ VGND VGND VPWR VPWR _0807_ sky130_fd_sc_hd__or4_1
XFILLER_0_50_85 VPWR VGND VPWR VGND sky130_ef_sc_hd__decap_12
XFILLER_0_7_258 VGND VGND VPWR VPWR sky130_fd_sc_hd__decap_8
X_1965_ _0673_ VGND VGND VPWR VPWR _0303_ sky130_fd_sc_hd__clkbuf_1
XFILLER_0_59_61 VGND VGND VPWR VPWR sky130_fd_sc_hd__fill_1
X_1896_ _0638_ VGND VGND VPWR VPWR _0091_ sky130_fd_sc_hd__inv_2
XFILLER_0_52_3 VGND VGND VPWR VPWR sky130_fd_sc_hd__decap_4
XFILLER_0_46_172 VGND VGND VPWR VPWR sky130_fd_sc_hd__fill_1
Xhold8 _0446_ VGND VGND VPWR VPWR net22 sky130_fd_sc_hd__dlygate4sd3_1
X_1750_ _0559_ VGND VGND VPWR VPWR _0059_ sky130_fd_sc_hd__inv_2
XFILLER_0_52_153 VPWR VGND VPWR VGND sky130_ef_sc_hd__decap_12
X_1681_ net200 _0506_ _0513_ VGND VGND VPWR VPWR _0514_ sky130_fd_sc_hd__a21oi_1
X_2164_ clknet_leaf_3_clk _0244_ _0074_ VGND VGND VPWR VPWR dual_watchdog_inst.watchdog_fc.rising_edge_timeout.assert_time\[17\]
+ sky130_fd_sc_hd__dfrtp_1
XFILLER_0_29_53 VGND VGND VPWR VPWR sky130_fd_sc_hd__decap_3
X_2233_ clknet_leaf_0_clk _0019_ net12 VGND VGND VPWR VPWR dual_watchdog_inst.watchdog_fc.falling_edge_timeout.internal_count\[24\]
+ sky130_fd_sc_hd__dfrtp_2
X_2095_ clknet_leaf_12_clk _0175_ VGND VGND VPWR VPWR uart_tx_jetson_inst.prescale_reg\[18\]
+ sky130_fd_sc_hd__dfxtp_1
XFILLER_0_45_52 VGND VGND VPWR VPWR sky130_fd_sc_hd__decap_4
X_1046_ dual_watchdog_inst.watchdog_fc.rising_edge_timeout.assert_time\[19\] dual_watchdog_inst.watchdog_fc.rising_edge_timeout.assert_time\[18\]
+ dual_watchdog_inst.watchdog_fc.rising_edge_timeout.assert_time\[17\] _0747_ VGND
+ VGND VPWR VPWR _0748_ sky130_fd_sc_hd__and4_1
X_1115_ _0793_ VGND VGND VPWR VPWR _0230_ sky130_fd_sc_hd__clkbuf_1
XFILLER_0_43_131 VGND VGND VPWR VPWR sky130_fd_sc_hd__decap_8
X_1948_ _0655_ _0661_ VGND VGND VPWR VPWR _0662_ sky130_fd_sc_hd__and2_1
X_1879_ uart_tx_raspi_inst.bit_cnt\[3\] uart_tx_raspi_inst.bit_cnt\[2\] _0631_ VGND
+ VGND VPWR VPWR _0632_ sky130_fd_sc_hd__o21bai_1
XFILLER_0_31_337 VGND VGND VPWR VPWR sky130_fd_sc_hd__decap_8
XFILLER_0_3_261 VPWR VGND VPWR VGND sky130_ef_sc_hd__decap_12
XFILLER_0_34_197 VGND VGND VPWR VPWR sky130_fd_sc_hd__fill_2
Xclkbuf_2_3__f_clk clknet_0_clk VGND VGND VPWR VPWR clknet_2_3__leaf_clk sky130_fd_sc_hd__clkbuf_16
X_1802_ _0579_ net154 _0571_ VGND VGND VPWR VPWR _0580_ sky130_fd_sc_hd__mux2_1
X_1733_ _0540_ _0471_ net207 VGND VGND VPWR VPWR _0551_ sky130_fd_sc_hd__o21a_1
XFILLER_0_13_326 VGND VGND VPWR VPWR sky130_fd_sc_hd__decap_8
XFILLER_0_40_134 VGND VGND VPWR VPWR sky130_fd_sc_hd__decap_6
Xhold216 uart_rx_jetson_inst.prescale_reg\[3\] VGND VGND VPWR VPWR net230 sky130_fd_sc_hd__dlygate4sd3_1
XFILLER_0_0_253 VPWR VGND VPWR VGND sky130_ef_sc_hd__decap_12
X_1595_ rst_cnt\[4\] _0926_ net41 VGND VGND VPWR VPWR _0449_ sky130_fd_sc_hd__a21oi_1
X_1664_ _0475_ _0498_ VGND VGND VPWR VPWR _0499_ sky130_fd_sc_hd__nand2_2
Xhold205 dual_watchdog_inst.watchdog_fc.falling_edge_timeout.internal_count\[19\]
+ VGND VGND VPWR VPWR net219 sky130_fd_sc_hd__dlygate4sd3_1
X_2147_ clknet_leaf_3_clk _0227_ _0057_ VGND VGND VPWR VPWR dual_watchdog_inst.watchdog_fc.rising_edge_timeout.assert_time\[0\]
+ sky130_fd_sc_hd__dfstp_1
X_2216_ clknet_leaf_26_clk _0027_ net11 VGND VGND VPWR VPWR dual_watchdog_inst.watchdog_fc.falling_edge_timeout.internal_count\[7\]
+ sky130_fd_sc_hd__dfrtp_1
X_1029_ dual_watchdog_inst.watchdog_fc.rising_edge_timeout.internal_count\[21\] dual_watchdog_inst.watchdog_fc.rising_edge_timeout.internal_count\[20\]
+ dual_watchdog_inst.watchdog_fc.rising_edge_timeout.internal_count\[25\] dual_watchdog_inst.watchdog_fc.rising_edge_timeout.internal_count\[24\]
+ VGND VGND VPWR VPWR _0732_ sky130_fd_sc_hd__nand4_1
X_2078_ clknet_leaf_16_clk _0158_ VGND VGND VPWR VPWR uart_tx_jetson_inst.prescale_reg\[1\]
+ sky130_fd_sc_hd__dfxtp_1
XFILLER_0_16_186 VGND VGND VPWR VPWR sky130_fd_sc_hd__decap_4
X_1380_ _0985_ VGND VGND VPWR VPWR _0124_ sky130_fd_sc_hd__clkbuf_1
XFILLER_0_22_189 VGND VGND VPWR VPWR sky130_fd_sc_hd__fill_2
XFILLER_0_26_21 VGND VGND VPWR VPWR sky130_fd_sc_hd__decap_6
X_2001_ _0698_ VGND VGND VPWR VPWR _0314_ sky130_fd_sc_hd__clkbuf_1
XFILLER_0_42_75 VGND VGND VPWR VPWR sky130_fd_sc_hd__decap_8
XFILLER_0_42_64 VGND VGND VPWR VPWR sky130_fd_sc_hd__decap_6
XFILLER_0_53_281 VGND VGND VPWR VPWR sky130_fd_sc_hd__decap_3
XFILLER_0_5_312 VPWR VGND VPWR VGND sky130_ef_sc_hd__decap_12
X_1716_ uart_rx_jetson_inst.prescale_reg\[8\] _0537_ VGND VGND VPWR VPWR _0539_ sky130_fd_sc_hd__or2_1
XTAP_384 VGND VPWR sky130_fd_sc_hd__tapvpwrvgnd_1
XTAP_373 VGND VPWR sky130_fd_sc_hd__tapvpwrvgnd_1
XTAP_362 VGND VPWR sky130_fd_sc_hd__tapvpwrvgnd_1
XTAP_351 VGND VPWR sky130_fd_sc_hd__tapvpwrvgnd_1
XTAP_340 VGND VPWR sky130_fd_sc_hd__tapvpwrvgnd_1
X_1578_ uart_tx_jetson_inst.bit_cnt\[3\] uart_tx_jetson_inst.bit_cnt\[2\] _0439_ VGND
+ VGND VPWR VPWR _0440_ sky130_fd_sc_hd__o21ai_1
X_1647_ _0986_ _0486_ VGND VGND VPWR VPWR _0487_ sky130_fd_sc_hd__and2b_1
XFILLER_0_6_97 VGND VGND VPWR VPWR sky130_fd_sc_hd__decap_3
XFILLER_0_13_178 VGND VGND VPWR VPWR sky130_fd_sc_hd__decap_8
XTAP_395 VGND VPWR sky130_fd_sc_hd__tapvpwrvgnd_1
XPHY_13 VGND VGND VPWR VPWR sky130_fd_sc_hd__decap_3
XPHY_24 VGND VGND VPWR VPWR sky130_fd_sc_hd__decap_3
XPHY_35 VGND VGND VPWR VPWR sky130_fd_sc_hd__decap_3
XPHY_46 VGND VGND VPWR VPWR sky130_fd_sc_hd__decap_3
XPHY_79 VGND VGND VPWR VPWR sky130_fd_sc_hd__decap_3
XFILLER_0_36_259 VGND VGND VPWR VPWR sky130_fd_sc_hd__fill_1
XPHY_68 VGND VGND VPWR VPWR sky130_fd_sc_hd__decap_3
XPHY_57 VGND VGND VPWR VPWR sky130_fd_sc_hd__decap_3
XFILLER_0_4_3 VGND VGND VPWR VPWR sky130_fd_sc_hd__decap_6
XFILLER_0_59_329 VGND VGND VPWR VPWR sky130_fd_sc_hd__decap_6
XFILLER_0_35_281 VGND VGND VPWR VPWR sky130_fd_sc_hd__decap_8
XFILLER_0_12_78 VGND VGND VPWR VPWR sky130_fd_sc_hd__decap_6
X_1501_ uart_tx_jetson_inst.s_axis_tready_reg _0383_ _0384_ VGND VGND VPWR VPWR _0385_
+ sky130_fd_sc_hd__a21o_1
X_1432_ net224 _0332_ VGND VGND VPWR VPWR _0335_ sky130_fd_sc_hd__nand2_1
X_1363_ _0971_ VGND VGND VPWR VPWR _0972_ sky130_fd_sc_hd__buf_6
XFILLER_0_10_137 VGND VGND VPWR VPWR sky130_fd_sc_hd__decap_3
X_1294_ dual_watchdog_inst.watchdog_fc.rising_edge_timeout.internal_count\[19\] _0906_
+ _0917_ VGND VGND VPWR VPWR _0918_ sky130_fd_sc_hd__and3_1
XFILLER_0_5_164 VGND VGND VPWR VPWR sky130_fd_sc_hd__decap_4
XTAP_170 VGND VPWR sky130_fd_sc_hd__tapvpwrvgnd_1
XTAP_181 VGND VPWR sky130_fd_sc_hd__tapvpwrvgnd_1
XTAP_192 VGND VPWR sky130_fd_sc_hd__tapvpwrvgnd_1
XFILLER_0_17_281 VPWR VGND VPWR VGND sky130_ef_sc_hd__decap_12
XFILLER_0_55_310 VGND VGND VPWR VPWR sky130_fd_sc_hd__decap_8
X_1981_ dual_watchdog_inst.watchdog_fc.falling_edge_timeout.assert_time\[20\] _0682_
+ VGND VGND VPWR VPWR _0684_ sky130_fd_sc_hd__and2_1
XFILLER_0_23_55 VGND VGND VPWR VPWR sky130_fd_sc_hd__fill_1
XFILLER_0_48_85 VGND VGND VPWR VPWR sky130_fd_sc_hd__fill_1
X_1415_ net108 net18 VGND VGND VPWR VPWR _1014_ sky130_fd_sc_hd__nand2_1
X_1346_ _0957_ net146 _0945_ VGND VGND VPWR VPWR _0958_ sky130_fd_sc_hd__mux2_1
X_1277_ dual_watchdog_inst.watchdog_fc.rising_edge_timeout.internal_count\[15\] dual_watchdog_inst.watchdog_fc.rising_edge_timeout.internal_count\[18\]
+ _0733_ _0896_ VGND VGND VPWR VPWR _0906_ sky130_fd_sc_hd__and4_1
XFILLER_0_46_354 VGND VGND VPWR VPWR sky130_fd_sc_hd__decap_8
XFILLER_0_46_321 VGND VGND VPWR VPWR sky130_fd_sc_hd__decap_3
XFILLER_0_37_321 VPWR VGND VPWR VGND sky130_ef_sc_hd__decap_12
Xclkbuf_leaf_22_clk clknet_2_2__leaf_clk VGND VGND VPWR VPWR clknet_leaf_22_clk sky130_fd_sc_hd__clkbuf_16
X_2180_ clknet_leaf_12_clk _0260_ VGND VGND VPWR VPWR uart_tx_jetson_inst.data_reg\[3\]
+ sky130_fd_sc_hd__dfxtp_1
X_1200_ dual_watchdog_inst.watchdog_fc.falling_edge_timeout.internal_count\[19\] dual_watchdog_inst.watchdog_fc.falling_edge_timeout.internal_count\[18\]
+ _0804_ _0849_ VGND VGND VPWR VPWR _0855_ sky130_fd_sc_hd__and4_1
XFILLER_0_47_129 VPWR VGND VPWR VGND sky130_ef_sc_hd__decap_12
XFILLER_0_47_118 VGND VGND VPWR VPWR sky130_fd_sc_hd__decap_3
X_1062_ dual_watchdog_inst.watchdog_fc.rising_edge_timeout.assert_time\[22\] dual_watchdog_inst.watchdog_fc.rising_edge_timeout.assert_time\[21\]
+ dual_watchdog_inst.watchdog_fc.rising_edge_timeout.assert_time\[20\] _0754_ VGND
+ VGND VPWR VPWR _0761_ sky130_fd_sc_hd__and4_1
X_1131_ dual_watchdog_inst.watchdog_fc.falling_edge_timeout.internal_count\[7\] dual_watchdog_inst.watchdog_fc.falling_edge_timeout.internal_count\[9\]
+ dual_watchdog_inst.watchdog_fc.falling_edge_timeout.internal_count\[8\] dual_watchdog_inst.watchdog_fc.falling_edge_timeout.internal_count\[6\]
+ VGND VGND VPWR VPWR _0806_ sky130_fd_sc_hd__or4bb_1
XFILLER_0_18_99 VGND VGND VPWR VPWR sky130_fd_sc_hd__fill_2
Xclkbuf_leaf_13_clk clknet_2_3__leaf_clk VGND VGND VPWR VPWR clknet_leaf_13_clk sky130_fd_sc_hd__clkbuf_16
XFILLER_0_50_97 VGND VGND VPWR VPWR sky130_fd_sc_hd__fill_1
X_1895_ _0638_ VGND VGND VPWR VPWR _0090_ sky130_fd_sc_hd__inv_2
XFILLER_0_43_302 VGND VGND VPWR VPWR sky130_fd_sc_hd__decap_6
XFILLER_0_28_332 VPWR VGND VPWR VGND sky130_ef_sc_hd__decap_12
X_1964_ _0829_ _0671_ _0672_ VGND VGND VPWR VPWR _0673_ sky130_fd_sc_hd__and3_1
XFILLER_0_11_243 VGND VGND VPWR VPWR sky130_fd_sc_hd__fill_1
XFILLER_0_45_3 VPWR VGND VPWR VGND sky130_ef_sc_hd__decap_12
X_1329_ _0946_ VGND VGND VPWR VPWR _0112_ sky130_fd_sc_hd__clkbuf_1
Xhold9 rst_cnt\[6\] VGND VGND VPWR VPWR net23 sky130_fd_sc_hd__dlygate4sd3_1
XFILLER_0_52_121 VGND VGND VPWR VPWR sky130_fd_sc_hd__decap_8
XFILLER_0_25_335 VGND VGND VPWR VPWR sky130_fd_sc_hd__fill_1
XFILLER_0_52_165 VGND VGND VPWR VPWR sky130_fd_sc_hd__decap_8
XFILLER_0_29_21 VPWR VGND VPWR VGND sky130_ef_sc_hd__decap_12
X_1680_ _0504_ _0501_ _0498_ _0512_ VGND VGND VPWR VPWR _0513_ sky130_fd_sc_hd__and4_1
X_2163_ clknet_leaf_2_clk _0243_ _0073_ VGND VGND VPWR VPWR dual_watchdog_inst.watchdog_fc.rising_edge_timeout.assert_time\[16\]
+ sky130_fd_sc_hd__dfrtp_1
Xclkbuf_leaf_2_clk clknet_2_1__leaf_clk VGND VGND VPWR VPWR clknet_leaf_2_clk sky130_fd_sc_hd__clkbuf_16
X_1114_ _0740_ _0766_ _0792_ VGND VGND VPWR VPWR _0793_ sky130_fd_sc_hd__and3b_1
X_2232_ clknet_leaf_25_clk _0018_ net13 VGND VGND VPWR VPWR dual_watchdog_inst.watchdog_fc.falling_edge_timeout.internal_count\[23\]
+ sky130_fd_sc_hd__dfrtp_1
X_2094_ clknet_leaf_12_clk _0174_ VGND VGND VPWR VPWR uart_tx_jetson_inst.prescale_reg\[17\]
+ sky130_fd_sc_hd__dfxtp_1
X_1045_ _0746_ VGND VGND VPWR VPWR _0747_ sky130_fd_sc_hd__clkbuf_2
XFILLER_0_31_327 VGND VGND VPWR VPWR sky130_fd_sc_hd__fill_1
XFILLER_0_28_195 VGND VGND VPWR VPWR sky130_fd_sc_hd__fill_1
XFILLER_0_28_173 VGND VGND VPWR VPWR sky130_fd_sc_hd__decap_4
X_1947_ dual_watchdog_inst.watchdog_fc.falling_edge_timeout.assert_time\[9\] dual_watchdog_inst.watchdog_fc.falling_edge_timeout.assert_time\[8\]
+ VGND VGND VPWR VPWR _0661_ sky130_fd_sc_hd__and2_1
XFILLER_0_16_302 VGND VGND VPWR VPWR sky130_fd_sc_hd__decap_6
X_1878_ uart_tx_raspi_inst.bit_cnt\[1\] uart_tx_raspi_inst.bit_cnt\[0\] _0940_ _0941_
+ VGND VGND VPWR VPWR _0631_ sky130_fd_sc_hd__or4_4
XFILLER_0_3_273 VGND VGND VPWR VPWR sky130_fd_sc_hd__decap_6
XFILLER_0_19_162 VGND VGND VPWR VPWR sky130_fd_sc_hd__decap_3
XFILLER_0_34_176 VPWR VGND VPWR VGND sky130_ef_sc_hd__decap_12
XFILLER_0_57_213 VGND VGND VPWR VPWR sky130_fd_sc_hd__fill_2
XFILLER_0_15_34 VPWR VGND VPWR VGND sky130_ef_sc_hd__decap_12
X_1801_ uart_rx_raspi_inst.m_axis_tdata_reg\[4\] uart_tx_jetson_inst.data_reg\[5\]
+ _0383_ VGND VGND VPWR VPWR _0579_ sky130_fd_sc_hd__mux2_1
Xhold206 uart_rx_raspi_inst.prescale_reg\[11\] VGND VGND VPWR VPWR net220 sky130_fd_sc_hd__dlygate4sd3_1
XFILLER_0_31_55 VGND VGND VPWR VPWR sky130_fd_sc_hd__fill_1
XFILLER_0_31_11 VGND VGND VPWR VPWR sky130_fd_sc_hd__fill_1
XFILLER_0_25_121 VGND VGND VPWR VPWR sky130_fd_sc_hd__decap_3
Xhold217 dual_watchdog_inst.watchdog_fc.falling_edge_timeout.internal_count\[14\]
+ VGND VGND VPWR VPWR net231 sky130_fd_sc_hd__dlygate4sd3_1
X_1663_ uart_rx_jetson_inst.rxd_reg _0497_ VGND VGND VPWR VPWR _0498_ sky130_fd_sc_hd__nand2_1
XFILLER_0_13_316 VGND VGND VPWR VPWR sky130_fd_sc_hd__fill_1
X_1732_ uart_rx_jetson_inst.prescale_reg\[13\] _0540_ _0471_ VGND VGND VPWR VPWR _0550_
+ sky130_fd_sc_hd__nor3_1
XFILLER_0_40_179 VPWR VGND VPWR VGND sky130_ef_sc_hd__decap_12
XFILLER_0_0_221 VGND VGND VPWR VPWR sky130_fd_sc_hd__decap_3
XFILLER_0_0_265 VPWR VGND VPWR VGND sky130_ef_sc_hd__decap_12
X_1594_ net88 _0926_ _0448_ VGND VGND VPWR VPWR _0184_ sky130_fd_sc_hd__o21ba_1
XFILLER_0_56_85 VGND VGND VPWR VPWR sky130_fd_sc_hd__decap_4
X_2077_ clknet_leaf_16_clk _0157_ VGND VGND VPWR VPWR uart_tx_jetson_inst.prescale_reg\[0\]
+ sky130_fd_sc_hd__dfxtp_1
X_2215_ clknet_leaf_27_clk _0026_ net7 VGND VGND VPWR VPWR dual_watchdog_inst.watchdog_fc.falling_edge_timeout.internal_count\[6\]
+ sky130_fd_sc_hd__dfrtp_1
X_2146_ clknet_leaf_20_clk _0226_ VGND VGND VPWR VPWR uart_rx_jetson_inst.prescale_reg\[18\]
+ sky130_fd_sc_hd__dfxtp_1
X_1028_ _0728_ _0729_ _0730_ VGND VGND VPWR VPWR _0731_ sky130_fd_sc_hd__or3_1
XFILLER_0_16_110 VGND VGND VPWR VPWR sky130_fd_sc_hd__fill_1
XFILLER_0_31_113 VPWR VGND VPWR VGND sky130_ef_sc_hd__decap_12
XFILLER_0_39_279 VGND VGND VPWR VPWR sky130_fd_sc_hd__fill_1
XFILLER_0_22_157 VPWR VGND VPWR VGND sky130_ef_sc_hd__decap_12
X_2000_ _0696_ _0697_ VGND VGND VPWR VPWR _0698_ sky130_fd_sc_hd__and2b_1
Xsplit1 _0945_ VGND VGND VPWR VPWR net15 sky130_fd_sc_hd__buf_6
XFILLER_0_42_98 VGND VGND VPWR VPWR sky130_fd_sc_hd__fill_2
XFILLER_0_60_219 VGND VGND VPWR VPWR sky130_fd_sc_hd__decap_4
X_1646_ uart_rx_jetson_inst.m_axis_tdata_reg\[3\] uart_rx_jetson_inst.data_reg\[3\]
+ _0479_ VGND VGND VPWR VPWR _0486_ sky130_fd_sc_hd__mux2_1
XFILLER_0_5_324 VGND VGND VPWR VPWR sky130_fd_sc_hd__decap_3
X_1715_ _0537_ _0538_ _0536_ VGND VGND VPWR VPWR _0215_ sky130_fd_sc_hd__a21oi_1
XFILLER_0_13_102 VGND VGND VPWR VPWR sky130_fd_sc_hd__decap_8
XTAP_396 VGND VPWR sky130_fd_sc_hd__tapvpwrvgnd_1
XTAP_385 VGND VPWR sky130_fd_sc_hd__tapvpwrvgnd_1
XTAP_374 VGND VPWR sky130_fd_sc_hd__tapvpwrvgnd_1
XTAP_363 VGND VPWR sky130_fd_sc_hd__tapvpwrvgnd_1
XTAP_352 VGND VPWR sky130_fd_sc_hd__tapvpwrvgnd_1
XTAP_341 VGND VPWR sky130_fd_sc_hd__tapvpwrvgnd_1
X_1577_ uart_tx_jetson_inst.bit_cnt\[1\] _0436_ VGND VGND VPWR VPWR _0439_ sky130_fd_sc_hd__nor2_1
XTAP_330 VGND VPWR sky130_fd_sc_hd__tapvpwrvgnd_1
XPHY_69 VGND VGND VPWR VPWR sky130_fd_sc_hd__decap_3
XPHY_58 VGND VGND VPWR VPWR sky130_fd_sc_hd__decap_3
XPHY_14 VGND VGND VPWR VPWR sky130_fd_sc_hd__decap_3
X_2129_ clknet_leaf_22_clk _0209_ VGND VGND VPWR VPWR uart_rx_jetson_inst.prescale_reg\[1\]
+ sky130_fd_sc_hd__dfxtp_1
XPHY_25 VGND VGND VPWR VPWR sky130_fd_sc_hd__decap_3
XPHY_36 VGND VGND VPWR VPWR sky130_fd_sc_hd__decap_3
XPHY_47 VGND VGND VPWR VPWR sky130_fd_sc_hd__decap_3
X_1500_ uart_tx_jetson_inst.s_axis_tready_reg uart_rx_raspi_inst.m_axis_tvalid_reg
+ _0383_ VGND VGND VPWR VPWR _0384_ sky130_fd_sc_hd__a21oi_1
XFILLER_0_35_293 VGND VGND VPWR VPWR sky130_fd_sc_hd__decap_8
XFILLER_0_10_105 VPWR VGND VPWR VGND sky130_ef_sc_hd__decap_12
X_1293_ dual_watchdog_inst.watchdog_fc.rising_edge_timeout.internal_count\[21\] dual_watchdog_inst.watchdog_fc.rising_edge_timeout.internal_count\[20\]
+ dual_watchdog_inst.watchdog_fc.rising_edge_timeout.internal_count\[23\] dual_watchdog_inst.watchdog_fc.rising_edge_timeout.internal_count\[22\]
+ VGND VGND VPWR VPWR _0917_ sky130_fd_sc_hd__and4_1
X_1431_ _0998_ _0334_ _0328_ VGND VGND VPWR VPWR _0135_ sky130_fd_sc_hd__a21oi_1
XFILLER_0_37_43 VGND VGND VPWR VPWR sky130_fd_sc_hd__decap_8
X_1362_ uart_rx_raspi_inst.prescale_reg\[18\] _0970_ VGND VGND VPWR VPWR _0971_ sky130_fd_sc_hd__or2_4
XFILLER_0_18_205 VGND VGND VPWR VPWR sky130_fd_sc_hd__decap_3
XFILLER_0_18_238 VPWR VGND VPWR VGND sky130_ef_sc_hd__decap_12
X_1629_ uart_rx_jetson_inst.prescale_reg\[14\] uart_rx_jetson_inst.prescale_reg\[13\]
+ uart_rx_jetson_inst.prescale_reg\[8\] _0471_ VGND VGND VPWR VPWR _0472_ sky130_fd_sc_hd__or4_4
XTAP_171 VGND VPWR sky130_fd_sc_hd__tapvpwrvgnd_1
XTAP_160 VGND VPWR sky130_fd_sc_hd__tapvpwrvgnd_1
XTAP_182 VGND VPWR sky130_fd_sc_hd__tapvpwrvgnd_1
XTAP_193 VGND VPWR sky130_fd_sc_hd__tapvpwrvgnd_1
XFILLER_0_32_274 VPWR VGND VPWR VGND sky130_ef_sc_hd__decap_12
XFILLER_0_32_230 VPWR VGND VPWR VGND sky130_ef_sc_hd__decap_12
XFILLER_0_17_293 VGND VGND VPWR VPWR sky130_fd_sc_hd__fill_2
XFILLER_0_59_116 VPWR VGND VPWR VGND sky130_ef_sc_hd__decap_12
X_1980_ net107 _0681_ _0683_ _0841_ VGND VGND VPWR VPWR _0308_ sky130_fd_sc_hd__o211a_1
Xrebuffer1 _0965_ VGND VGND VPWR VPWR net30 sky130_fd_sc_hd__dlygate4sd1_1
XFILLER_0_23_263 VGND VGND VPWR VPWR sky130_fd_sc_hd__fill_1
XFILLER_0_23_285 VPWR VGND VPWR VGND sky130_ef_sc_hd__decap_12
X_1276_ _0733_ _0900_ net112 VGND VGND VPWR VPWR _0905_ sky130_fd_sc_hd__a21oi_1
X_1414_ _0972_ _0996_ _1012_ VGND VGND VPWR VPWR _1013_ sky130_fd_sc_hd__or3_1
XFILLER_0_3_55 VGND VGND VPWR VPWR sky130_fd_sc_hd__fill_1
X_1345_ uart_rx_jetson_inst.m_axis_tdata_reg\[6\] uart_tx_raspi_inst.data_reg\[7\]
+ _0930_ VGND VGND VPWR VPWR _0957_ sky130_fd_sc_hd__mux2_1
XFILLER_0_14_274 VGND VGND VPWR VPWR sky130_fd_sc_hd__decap_4
XFILLER_0_52_314 VGND VGND VPWR VPWR sky130_fd_sc_hd__decap_4
XFILLER_0_37_333 VGND VGND VPWR VPWR sky130_fd_sc_hd__decap_3
X_1130_ dual_watchdog_inst.watchdog_fc.falling_edge_timeout.internal_count\[1\] _0803_
+ dual_watchdog_inst.watchdog_fc.falling_edge_timeout.internal_count\[0\] _0804_ VGND
+ VGND VPWR VPWR _0805_ sky130_fd_sc_hd__or4b_1
X_1061_ _0759_ _0757_ _0760_ VGND VGND VPWR VPWR _0251_ sky130_fd_sc_hd__nor3_1
XFILLER_0_34_44 VPWR VGND VPWR VGND sky130_ef_sc_hd__decap_12
XFILLER_0_55_196 VGND VGND VPWR VPWR sky130_fd_sc_hd__decap_8
XFILLER_0_55_141 VPWR VGND VPWR VGND sky130_ef_sc_hd__decap_12
X_1894_ _0638_ VGND VGND VPWR VPWR _0089_ sky130_fd_sc_hd__inv_2
XFILLER_0_28_344 VGND VGND VPWR VPWR sky130_fd_sc_hd__decap_4
X_1963_ dual_watchdog_inst.watchdog_fc.falling_edge_timeout.assert_time\[14\] _0670_
+ VGND VGND VPWR VPWR _0672_ sky130_fd_sc_hd__nand2_1
XFILLER_0_11_200 VGND VGND VPWR VPWR sky130_fd_sc_hd__decap_6
XFILLER_0_11_222 VGND VGND VPWR VPWR sky130_fd_sc_hd__fill_2
X_1259_ _0893_ VGND VGND VPWR VPWR _0033_ sky130_fd_sc_hd__clkbuf_1
X_1328_ _0931_ net165 _0945_ VGND VGND VPWR VPWR _0946_ sky130_fd_sc_hd__mux2_1
XFILLER_0_38_108 VGND VGND VPWR VPWR sky130_fd_sc_hd__decap_8
XFILLER_0_19_311 VGND VGND VPWR VPWR sky130_fd_sc_hd__fill_1
XFILLER_0_19_333 VGND VGND VPWR VPWR sky130_fd_sc_hd__decap_3
XFILLER_0_34_336 VGND VGND VPWR VPWR sky130_fd_sc_hd__fill_1
XFILLER_0_29_108 VGND VGND VPWR VPWR sky130_fd_sc_hd__decap_4
XFILLER_0_37_174 VGND VGND VPWR VPWR sky130_fd_sc_hd__decap_8
XFILLER_0_20_24 VGND VGND VPWR VPWR sky130_fd_sc_hd__decap_4
XFILLER_0_29_33 VPWR VGND VPWR VGND sky130_ef_sc_hd__decap_12
X_2231_ clknet_leaf_24_clk _0017_ net13 VGND VGND VPWR VPWR dual_watchdog_inst.watchdog_fc.falling_edge_timeout.internal_count\[22\]
+ sky130_fd_sc_hd__dfrtp_1
X_2093_ clknet_leaf_12_clk _0173_ VGND VGND VPWR VPWR uart_tx_jetson_inst.prescale_reg\[16\]
+ sky130_fd_sc_hd__dfxtp_1
XFILLER_0_45_65 VGND VGND VPWR VPWR sky130_fd_sc_hd__fill_1
X_2162_ clknet_leaf_8_clk net67 _0072_ VGND VGND VPWR VPWR dual_watchdog_inst.watchdog_fc.rising_edge_timeout.assert_time\[15\]
+ sky130_fd_sc_hd__dfrtp_1
X_1044_ dual_watchdog_inst.watchdog_fc.rising_edge_timeout.assert_time\[16\] dual_watchdog_inst.watchdog_fc.rising_edge_timeout.assert_time\[15\]
+ dual_watchdog_inst.watchdog_fc.rising_edge_timeout.assert_time\[14\] _0745_ VGND
+ VGND VPWR VPWR _0746_ sky130_fd_sc_hd__and4_1
X_1113_ dual_watchdog_inst.watchdog_fc.rising_edge_timeout.assert_time\[2\] dual_watchdog_inst.watchdog_fc.rising_edge_timeout.assert_time\[1\]
+ dual_watchdog_inst.watchdog_fc.rising_edge_timeout.assert_time\[0\] dual_watchdog_inst.watchdog_fc.rising_edge_timeout.assert_time\[3\]
+ VGND VGND VPWR VPWR _0792_ sky130_fd_sc_hd__a31o_1
XFILLER_0_31_306 VGND VGND VPWR VPWR sky130_fd_sc_hd__fill_2
X_1946_ net147 VGND VGND VPWR VPWR _0660_ sky130_fd_sc_hd__inv_2
XFILLER_0_9_65 VGND VGND VPWR VPWR sky130_fd_sc_hd__fill_1
X_1877_ net59 _0628_ VGND VGND VPWR VPWR _0630_ sky130_fd_sc_hd__nand2_1
XFILLER_0_34_155 VGND VGND VPWR VPWR sky130_fd_sc_hd__fill_2
XFILLER_0_19_196 VGND VGND VPWR VPWR sky130_fd_sc_hd__fill_1
XFILLER_0_34_188 VGND VGND VPWR VPWR sky130_fd_sc_hd__decap_8
XFILLER_0_57_269 VGND VGND VPWR VPWR sky130_fd_sc_hd__decap_8
X_1800_ _0578_ VGND VGND VPWR VPWR _0260_ sky130_fd_sc_hd__clkbuf_1
XFILLER_0_15_46 VGND VGND VPWR VPWR sky130_fd_sc_hd__decap_4
XFILLER_0_15_57 VGND VGND VPWR VPWR sky130_fd_sc_hd__fill_2
XFILLER_0_25_111 VGND VGND VPWR VPWR sky130_fd_sc_hd__fill_1
X_1662_ uart_rx_jetson_inst.bit_cnt\[2\] uart_rx_jetson_inst.bit_cnt\[1\] uart_rx_jetson_inst.bit_cnt\[3\]
+ VGND VGND VPWR VPWR _0497_ sky130_fd_sc_hd__o21a_1
X_1731_ _0536_ _0549_ VGND VGND VPWR VPWR _0220_ sky130_fd_sc_hd__nor2_1
Xhold207 dual_watchdog_inst.watchdog_fc.falling_edge_timeout.assert_time\[16\] VGND
+ VGND VPWR VPWR net221 sky130_fd_sc_hd__dlygate4sd3_1
Xhold218 uart_rx_jetson_inst.data_reg\[7\] VGND VGND VPWR VPWR net232 sky130_fd_sc_hd__dlygate4sd3_1
XFILLER_0_0_277 VGND VGND VPWR VPWR sky130_fd_sc_hd__decap_3
X_1593_ rst_cnt\[4\] _0926_ _0000_ VGND VGND VPWR VPWR _0448_ sky130_fd_sc_hd__and3_1
X_2214_ clknet_leaf_26_clk _0025_ net11 VGND VGND VPWR VPWR dual_watchdog_inst.watchdog_fc.falling_edge_timeout.internal_count\[5\]
+ sky130_fd_sc_hd__dfrtp_1
X_1027_ dual_watchdog_inst.watchdog_fc.rising_edge_timeout.internal_count\[10\] dual_watchdog_inst.watchdog_fc.rising_edge_timeout.internal_count\[13\]
+ dual_watchdog_inst.watchdog_fc.rising_edge_timeout.internal_count\[12\] dual_watchdog_inst.watchdog_fc.rising_edge_timeout.internal_count\[11\]
+ VGND VGND VPWR VPWR _0730_ sky130_fd_sc_hd__or4bb_1
X_2076_ clknet_leaf_8_clk _0156_ VGND VGND VPWR VPWR uart_rx_raspi_inst.rxd_reg sky130_fd_sc_hd__dfxtp_2
X_2145_ clknet_leaf_19_clk net48 VGND VGND VPWR VPWR uart_rx_jetson_inst.prescale_reg\[17\]
+ sky130_fd_sc_hd__dfxtp_1
XFILLER_0_56_291 VPWR VGND VPWR VGND sky130_ef_sc_hd__decap_12
X_1929_ _0648_ VGND VGND VPWR VPWR _0292_ sky130_fd_sc_hd__clkbuf_1
XFILLER_0_31_169 VGND VGND VPWR VPWR sky130_fd_sc_hd__decap_8
XFILLER_0_31_147 VGND VGND VPWR VPWR sky130_fd_sc_hd__fill_2
XFILLER_0_31_125 VGND VGND VPWR VPWR sky130_fd_sc_hd__fill_1
XFILLER_0_10_309 VGND VGND VPWR VPWR sky130_fd_sc_hd__decap_6
XFILLER_0_22_169 VPWR VGND VPWR VGND sky130_ef_sc_hd__decap_12
Xhold90 uart_rx_raspi_inst.bit_cnt\[1\] VGND VGND VPWR VPWR net104 sky130_fd_sc_hd__dlygate4sd3_1
XFILLER_0_60_209 VGND VGND VPWR VPWR sky130_fd_sc_hd__decap_4
XFILLER_0_53_261 VGND VGND VPWR VPWR sky130_fd_sc_hd__decap_8
X_1576_ net63 _0436_ VGND VGND VPWR VPWR _0438_ sky130_fd_sc_hd__nand2_1
X_1645_ _0485_ VGND VGND VPWR VPWR _0198_ sky130_fd_sc_hd__clkbuf_1
X_1714_ net40 _0470_ VGND VGND VPWR VPWR _0538_ sky130_fd_sc_hd__nand2_1
XTAP_397 VGND VPWR sky130_fd_sc_hd__tapvpwrvgnd_1
XTAP_386 VGND VPWR sky130_fd_sc_hd__tapvpwrvgnd_1
XTAP_375 VGND VPWR sky130_fd_sc_hd__tapvpwrvgnd_1
XTAP_364 VGND VPWR sky130_fd_sc_hd__tapvpwrvgnd_1
XTAP_353 VGND VPWR sky130_fd_sc_hd__tapvpwrvgnd_1
XTAP_342 VGND VPWR sky130_fd_sc_hd__tapvpwrvgnd_1
XTAP_331 VGND VPWR sky130_fd_sc_hd__tapvpwrvgnd_1
XTAP_320 VGND VPWR sky130_fd_sc_hd__tapvpwrvgnd_1
X_2059_ clknet_leaf_1_clk net32 VGND VGND VPWR VPWR uart_rx_raspi_inst.prescale_reg\[6\]
+ sky130_fd_sc_hd__dfxtp_1
XPHY_59 VGND VGND VPWR VPWR sky130_fd_sc_hd__decap_3
XPHY_15 VGND VGND VPWR VPWR sky130_fd_sc_hd__decap_3
X_2128_ clknet_leaf_21_clk _0208_ VGND VGND VPWR VPWR uart_rx_jetson_inst.prescale_reg\[0\]
+ sky130_fd_sc_hd__dfxtp_1
XPHY_26 VGND VGND VPWR VPWR sky130_fd_sc_hd__decap_3
XPHY_37 VGND VGND VPWR VPWR sky130_fd_sc_hd__decap_3
XPHY_48 VGND VGND VPWR VPWR sky130_fd_sc_hd__decap_3
XFILLER_0_44_250 VGND VGND VPWR VPWR sky130_fd_sc_hd__fill_2
XFILLER_0_50_253 VGND VGND VPWR VPWR sky130_fd_sc_hd__decap_8
X_1430_ _0332_ _0333_ _1001_ VGND VGND VPWR VPWR _0334_ sky130_fd_sc_hd__a21o_1
XFILLER_0_10_117 VGND VGND VPWR VPWR sky130_fd_sc_hd__fill_2
X_1292_ net137 VGND VGND VPWR VPWR _0916_ sky130_fd_sc_hd__inv_2
XFILLER_0_37_55 VGND VGND VPWR VPWR sky130_fd_sc_hd__fill_1
X_1361_ net64 uart_rx_raspi_inst.prescale_reg\[16\] _0969_ VGND VGND VPWR VPWR _0970_
+ sky130_fd_sc_hd__or3_4
XFILLER_0_53_98 VGND VGND VPWR VPWR sky130_fd_sc_hd__decap_8
XFILLER_0_53_87 VGND VGND VPWR VPWR sky130_fd_sc_hd__fill_1
XFILLER_0_41_220 VGND VGND VPWR VPWR sky130_fd_sc_hd__fill_1
X_1559_ _0426_ _0427_ _0414_ VGND VGND VPWR VPWR _0170_ sky130_fd_sc_hd__a21oi_1
XTAP_150 VGND VPWR sky130_fd_sc_hd__tapvpwrvgnd_1
XFILLER_0_1_361 VGND VGND VPWR VPWR sky130_fd_sc_hd__fill_1
X_1628_ uart_rx_jetson_inst.prescale_reg\[12\] uart_rx_jetson_inst.prescale_reg\[11\]
+ uart_rx_jetson_inst.prescale_reg\[10\] uart_rx_jetson_inst.prescale_reg\[9\] VGND
+ VGND VPWR VPWR _0471_ sky130_fd_sc_hd__or4_4
XTAP_161 VGND VPWR sky130_fd_sc_hd__tapvpwrvgnd_1
XTAP_172 VGND VPWR sky130_fd_sc_hd__tapvpwrvgnd_1
XTAP_183 VGND VPWR sky130_fd_sc_hd__tapvpwrvgnd_1
XTAP_194 VGND VPWR sky130_fd_sc_hd__tapvpwrvgnd_1
XFILLER_0_32_286 VGND VGND VPWR VPWR sky130_fd_sc_hd__decap_8
XFILLER_0_32_253 VGND VGND VPWR VPWR sky130_fd_sc_hd__decap_4
XFILLER_0_32_242 VGND VGND VPWR VPWR sky130_fd_sc_hd__decap_4
XFILLER_0_17_250 VPWR VGND VPWR VGND sky130_ef_sc_hd__decap_12
XFILLER_0_59_128 VPWR VGND VPWR VGND sky130_ef_sc_hd__decap_12
XFILLER_0_55_345 VPWR VGND VPWR VGND sky130_ef_sc_hd__decap_12
Xrebuffer2 net186 VGND VGND VPWR VPWR net16 sky130_fd_sc_hd__clkbuf_1
X_1413_ uart_rx_raspi_inst.rxd_reg _0997_ _1010_ _1011_ VGND VGND VPWR VPWR _1012_
+ sky130_fd_sc_hd__a22o_1
X_1275_ _0904_ VGND VGND VPWR VPWR _0038_ sky130_fd_sc_hd__clkbuf_1
XFILLER_0_48_98 VGND VGND VPWR VPWR sky130_fd_sc_hd__decap_6
X_1344_ _0956_ VGND VGND VPWR VPWR _0117_ sky130_fd_sc_hd__clkbuf_1
XFILLER_0_13_90 VPWR VGND VPWR VGND sky130_ef_sc_hd__decap_12
XFILLER_0_14_231 VGND VGND VPWR VPWR sky130_fd_sc_hd__decap_8
XFILLER_0_14_253 VGND VGND VPWR VPWR sky130_fd_sc_hd__decap_4
XFILLER_0_14_297 VGND VGND VPWR VPWR sky130_fd_sc_hd__decap_8
XFILLER_0_20_278 VGND VGND VPWR VPWR sky130_fd_sc_hd__decap_4
X_1060_ _0754_ _0749_ dual_watchdog_inst.watchdog_fc.rising_edge_timeout.assert_time\[24\]
+ VGND VGND VPWR VPWR _0760_ sky130_fd_sc_hd__a21oi_1
XFILLER_0_18_24 VGND VGND VPWR VPWR sky130_fd_sc_hd__decap_4
XFILLER_0_18_79 VGND VGND VPWR VPWR sky130_fd_sc_hd__decap_4
XFILLER_0_34_89 VGND VGND VPWR VPWR sky130_fd_sc_hd__fill_1
XFILLER_0_34_56 VPWR VGND VPWR VGND sky130_ef_sc_hd__decap_12
X_1962_ dual_watchdog_inst.watchdog_fc.falling_edge_timeout.assert_time\[14\] _0670_
+ VGND VGND VPWR VPWR _0671_ sky130_fd_sc_hd__or2_1
XFILLER_0_55_153 VPWR VGND VPWR VGND sky130_ef_sc_hd__decap_12
XFILLER_0_50_77 VGND VGND VPWR VPWR sky130_fd_sc_hd__fill_1
X_1893_ _0638_ VGND VGND VPWR VPWR _0088_ sky130_fd_sc_hd__inv_2
X_1258_ _0738_ _0891_ _0892_ VGND VGND VPWR VPWR _0893_ sky130_fd_sc_hd__and3_1
X_1189_ dual_watchdog_inst.watchdog_fc.falling_edge_timeout.internal_count\[14\] _0845_
+ net203 VGND VGND VPWR VPWR _0848_ sky130_fd_sc_hd__a21oi_1
X_1327_ _0944_ VGND VGND VPWR VPWR _0945_ sky130_fd_sc_hd__buf_6
XFILLER_0_34_326 VGND VGND VPWR VPWR sky130_fd_sc_hd__fill_2
XFILLER_0_6_250 VGND VGND VPWR VPWR sky130_fd_sc_hd__fill_2
XFILLER_0_6_272 VGND VGND VPWR VPWR sky130_fd_sc_hd__fill_1
XFILLER_0_52_134 VGND VGND VPWR VPWR sky130_fd_sc_hd__decap_6
XFILLER_0_52_112 VGND VGND VPWR VPWR sky130_fd_sc_hd__fill_1
XFILLER_0_25_348 VPWR VGND VPWR VGND sky130_ef_sc_hd__decap_12
XFILLER_0_29_45 VGND VGND VPWR VPWR sky130_fd_sc_hd__decap_8
X_2230_ clknet_leaf_23_clk _0016_ net13 VGND VGND VPWR VPWR dual_watchdog_inst.watchdog_fc.falling_edge_timeout.internal_count\[21\]
+ sky130_fd_sc_hd__dfrtp_1
X_2092_ clknet_leaf_13_clk _0172_ VGND VGND VPWR VPWR uart_tx_jetson_inst.prescale_reg\[15\]
+ sky130_fd_sc_hd__dfxtp_1
X_2161_ clknet_leaf_1_clk _0241_ _0071_ VGND VGND VPWR VPWR dual_watchdog_inst.watchdog_fc.rising_edge_timeout.assert_time\[14\]
+ sky130_fd_sc_hd__dfrtp_1
X_1043_ _0744_ VGND VGND VPWR VPWR _0745_ sky130_fd_sc_hd__clkbuf_2
X_1112_ _0759_ _0791_ VGND VGND VPWR VPWR _0231_ sky130_fd_sc_hd__nor2_1
X_1945_ _0659_ VGND VGND VPWR VPWR _0297_ sky130_fd_sc_hd__clkbuf_1
XFILLER_0_0_57 VPWR VGND VPWR VGND sky130_ef_sc_hd__decap_12
XFILLER_0_43_167 VGND VGND VPWR VPWR sky130_fd_sc_hd__fill_1
XFILLER_0_43_145 VGND VGND VPWR VPWR sky130_fd_sc_hd__fill_2
X_1876_ _0628_ _0629_ _1002_ VGND VGND VPWR VPWR _0285_ sky130_fd_sc_hd__a21oi_1
XFILLER_0_9_55 VGND VGND VPWR VPWR sky130_fd_sc_hd__fill_1
XFILLER_0_19_153 VGND VGND VPWR VPWR sky130_fd_sc_hd__fill_1
XFILLER_0_57_259 VGND VGND VPWR VPWR sky130_fd_sc_hd__fill_1
XFILLER_0_31_57 VGND VGND VPWR VPWR sky130_fd_sc_hd__decap_6
XFILLER_0_40_104 VGND VGND VPWR VPWR sky130_fd_sc_hd__fill_1
Xhold208 dual_watchdog_inst.watchdog_fc.rising_edge_timeout.assert_time\[4\] VGND
+ VGND VPWR VPWR net222 sky130_fd_sc_hd__dlygate4sd3_1
Xhold219 rst_cnt\[1\] VGND VGND VPWR VPWR net233 sky130_fd_sc_hd__dlygate4sd3_1
X_1592_ _0926_ _0447_ _0000_ VGND VGND VPWR VPWR _0183_ sky130_fd_sc_hd__o21ai_1
X_1730_ _0540_ _0471_ _0548_ VGND VGND VPWR VPWR _0549_ sky130_fd_sc_hd__o21a_1
X_1661_ net229 VGND VGND VPWR VPWR _0496_ sky130_fd_sc_hd__inv_2
X_2213_ clknet_leaf_27_clk _0024_ net11 VGND VGND VPWR VPWR dual_watchdog_inst.watchdog_fc.falling_edge_timeout.internal_count\[4\]
+ sky130_fd_sc_hd__dfrtp_1
X_2144_ clknet_leaf_19_clk _0224_ VGND VGND VPWR VPWR uart_rx_jetson_inst.prescale_reg\[16\]
+ sky130_fd_sc_hd__dfxtp_1
X_1026_ dual_watchdog_inst.watchdog_fc.rising_edge_timeout.internal_count\[15\] dual_watchdog_inst.watchdog_fc.rising_edge_timeout.internal_count\[19\]
+ dual_watchdog_inst.watchdog_fc.rising_edge_timeout.internal_count\[18\] dual_watchdog_inst.watchdog_fc.rising_edge_timeout.internal_count\[14\]
+ VGND VGND VPWR VPWR _0729_ sky130_fd_sc_hd__or4b_1
X_2075_ clknet_leaf_10_clk _0155_ VGND VGND VPWR VPWR uart_tx_jetson_inst.s_axis_tready_reg
+ sky130_fd_sc_hd__dfxtp_1
X_1859_ _0618_ _0619_ _0609_ VGND VGND VPWR VPWR _0278_ sky130_fd_sc_hd__a21oi_1
X_1928_ _0829_ _0646_ _0647_ VGND VGND VPWR VPWR _0648_ sky130_fd_sc_hd__and3_1
XFILLER_0_47_281 VGND VGND VPWR VPWR sky130_fd_sc_hd__decap_8
XFILLER_0_22_126 VGND VGND VPWR VPWR sky130_fd_sc_hd__fill_1
Xsplit3 _0977_ VGND VGND VPWR VPWR net17 sky130_fd_sc_hd__buf_6
Xhold91 dual_watchdog_inst.watchdog_fc.rising_edge_timeout.internal_count\[14\] VGND
+ VGND VPWR VPWR net105 sky130_fd_sc_hd__dlygate4sd3_1
Xhold80 _0626_ VGND VGND VPWR VPWR net94 sky130_fd_sc_hd__dlygate4sd3_1
XFILLER_0_53_240 VGND VGND VPWR VPWR sky130_fd_sc_hd__fill_1
XFILLER_0_5_337 VPWR VGND VPWR VGND sky130_ef_sc_hd__decap_12
X_1713_ uart_rx_jetson_inst.prescale_reg\[7\] _0470_ VGND VGND VPWR VPWR _0537_ sky130_fd_sc_hd__or2_1
X_1575_ _1009_ _0437_ VGND VGND VPWR VPWR _0176_ sky130_fd_sc_hd__nor2_1
XTAP_332 VGND VPWR sky130_fd_sc_hd__tapvpwrvgnd_1
XTAP_321 VGND VPWR sky130_fd_sc_hd__tapvpwrvgnd_1
XTAP_310 VGND VPWR sky130_fd_sc_hd__tapvpwrvgnd_1
X_1644_ _0986_ _0484_ VGND VGND VPWR VPWR _0485_ sky130_fd_sc_hd__and2b_1
XFILLER_0_6_34 VGND VGND VPWR VPWR sky130_fd_sc_hd__fill_1
XFILLER_0_6_23 VGND VGND VPWR VPWR sky130_fd_sc_hd__fill_2
XTAP_398 VGND VPWR sky130_fd_sc_hd__tapvpwrvgnd_1
XTAP_387 VGND VPWR sky130_fd_sc_hd__tapvpwrvgnd_1
XTAP_376 VGND VPWR sky130_fd_sc_hd__tapvpwrvgnd_1
XTAP_365 VGND VPWR sky130_fd_sc_hd__tapvpwrvgnd_1
XTAP_354 VGND VPWR sky130_fd_sc_hd__tapvpwrvgnd_1
XTAP_343 VGND VPWR sky130_fd_sc_hd__tapvpwrvgnd_1
X_2127_ clknet_leaf_23_clk _0207_ VGND VGND VPWR VPWR uart_rx_jetson_inst.bit_cnt\[3\]
+ sky130_fd_sc_hd__dfxtp_1
XFILLER_0_13_3 VGND VGND VPWR VPWR sky130_fd_sc_hd__decap_8
X_2058_ clknet_leaf_8_clk _0138_ VGND VGND VPWR VPWR uart_rx_raspi_inst.prescale_reg\[5\]
+ sky130_fd_sc_hd__dfxtp_1
XPHY_16 VGND VGND VPWR VPWR sky130_fd_sc_hd__decap_3
XFILLER_0_8_120 VGND VGND VPWR VPWR sky130_fd_sc_hd__fill_1
XPHY_27 VGND VGND VPWR VPWR sky130_fd_sc_hd__decap_3
XPHY_38 VGND VGND VPWR VPWR sky130_fd_sc_hd__decap_3
XPHY_49 VGND VGND VPWR VPWR sky130_fd_sc_hd__decap_3
XFILLER_0_8_197 VGND VGND VPWR VPWR sky130_fd_sc_hd__decap_4
XFILLER_0_50_265 VPWR VGND VPWR VGND sky130_ef_sc_hd__decap_12
X_1360_ net55 uart_rx_raspi_inst.prescale_reg\[7\] _0966_ _0968_ VGND VGND VPWR VPWR
+ _0969_ sky130_fd_sc_hd__or4_4
XFILLER_0_2_307 VGND VGND VPWR VPWR sky130_fd_sc_hd__fill_1
X_1291_ _0915_ VGND VGND VPWR VPWR _0044_ sky130_fd_sc_hd__clkbuf_1
XFILLER_0_37_34 VGND VGND VPWR VPWR sky130_fd_sc_hd__fill_2
XFILLER_0_37_23 VGND VGND VPWR VPWR sky130_fd_sc_hd__decap_3
XFILLER_0_58_321 VPWR VGND VPWR VGND sky130_ef_sc_hd__decap_12
XFILLER_0_53_55 VGND VGND VPWR VPWR sky130_fd_sc_hd__fill_1
XFILLER_0_26_262 VGND VGND VPWR VPWR sky130_fd_sc_hd__decap_6
XFILLER_0_5_189 VPWR VGND VPWR VGND sky130_ef_sc_hd__decap_12
XFILLER_0_5_156 VGND VGND VPWR VPWR sky130_fd_sc_hd__fill_1
X_1558_ uart_tx_jetson_inst.prescale_reg\[13\] _0425_ VGND VGND VPWR VPWR _0427_ sky130_fd_sc_hd__or2_1
X_1489_ uart_tx_jetson_inst.prescale_reg\[7\] uart_tx_jetson_inst.prescale_reg\[6\]
+ uart_tx_jetson_inst.prescale_reg\[5\] uart_tx_jetson_inst.prescale_reg\[4\] VGND
+ VGND VPWR VPWR _0374_ sky130_fd_sc_hd__or4_1
XTAP_162 VGND VPWR sky130_fd_sc_hd__tapvpwrvgnd_1
XTAP_151 VGND VPWR sky130_fd_sc_hd__tapvpwrvgnd_1
XTAP_140 VGND VPWR sky130_fd_sc_hd__tapvpwrvgnd_1
XTAP_173 VGND VPWR sky130_fd_sc_hd__tapvpwrvgnd_1
X_1627_ net28 uart_rx_jetson_inst.prescale_reg\[5\] uart_rx_jetson_inst.prescale_reg\[4\]
+ _0469_ VGND VGND VPWR VPWR _0470_ sky130_fd_sc_hd__or4_4
XTAP_184 VGND VPWR sky130_fd_sc_hd__tapvpwrvgnd_1
XTAP_195 VGND VPWR sky130_fd_sc_hd__tapvpwrvgnd_1
XFILLER_0_17_262 VGND VGND VPWR VPWR sky130_fd_sc_hd__decap_4
XFILLER_0_2_3 VPWR VGND VPWR VGND sky130_ef_sc_hd__decap_12
Xclkbuf_leaf_25_clk clknet_2_0__leaf_clk VGND VGND VPWR VPWR clknet_leaf_25_clk sky130_fd_sc_hd__clkbuf_16
XFILLER_0_23_47 VGND VGND VPWR VPWR sky130_fd_sc_hd__fill_1
XFILLER_0_55_357 VGND VGND VPWR VPWR sky130_fd_sc_hd__decap_4
Xrebuffer3 _0943_ VGND VGND VPWR VPWR net239 sky130_fd_sc_hd__dlygate4sd1_1
XFILLER_0_48_33 VGND VGND VPWR VPWR sky130_fd_sc_hd__decap_3
X_1412_ uart_rx_raspi_inst.bit_cnt\[2\] _1003_ VGND VGND VPWR VPWR _1011_ sky130_fd_sc_hd__or2_1
X_1343_ _0955_ net193 net15 VGND VGND VPWR VPWR _0956_ sky130_fd_sc_hd__mux2_2
X_1274_ _0766_ _0902_ _0903_ VGND VGND VPWR VPWR _0904_ sky130_fd_sc_hd__and3_1
XFILLER_0_3_57 VPWR VGND VPWR VGND sky130_ef_sc_hd__decap_12
XFILLER_0_58_195 VGND VGND VPWR VPWR sky130_fd_sc_hd__fill_1
Xclkbuf_leaf_16_clk clknet_2_3__leaf_clk VGND VGND VPWR VPWR clknet_leaf_16_clk sky130_fd_sc_hd__clkbuf_16
XFILLER_0_14_265 VGND VGND VPWR VPWR sky130_fd_sc_hd__fill_1
XFILLER_0_1_181 VPWR VGND VPWR VGND sky130_ef_sc_hd__decap_12
XFILLER_0_9_281 VPWR VGND VPWR VGND sky130_ef_sc_hd__decap_12
XFILLER_0_34_35 VGND VGND VPWR VPWR sky130_fd_sc_hd__fill_1
XFILLER_0_34_24 VGND VGND VPWR VPWR sky130_fd_sc_hd__decap_4
XFILLER_0_55_165 VGND VGND VPWR VPWR sky130_fd_sc_hd__decap_3
XFILLER_0_55_110 VGND VGND VPWR VPWR sky130_fd_sc_hd__fill_2
XFILLER_0_50_23 VGND VGND VPWR VPWR sky130_fd_sc_hd__decap_4
X_1892_ _0638_ VGND VGND VPWR VPWR _0087_ sky130_fd_sc_hd__inv_2
XFILLER_0_34_68 VPWR VGND VPWR VGND sky130_ef_sc_hd__decap_12
X_1961_ _0821_ _0668_ _0670_ VGND VGND VPWR VPWR _0302_ sky130_fd_sc_hd__nor3_1
Xclkbuf_leaf_5_clk clknet_2_1__leaf_clk VGND VGND VPWR VPWR clknet_leaf_5_clk sky130_fd_sc_hd__clkbuf_16
XFILLER_0_52_7 VGND VGND VPWR VPWR sky130_fd_sc_hd__fill_1
X_1326_ uart_rst _0940_ _0941_ _0943_ VGND VGND VPWR VPWR _0944_ sky130_fd_sc_hd__or4b_4
X_1257_ dual_watchdog_inst.watchdog_fc.rising_edge_timeout.internal_count\[12\] _0889_
+ VGND VGND VPWR VPWR _0892_ sky130_fd_sc_hd__nand2_1
X_1188_ net231 _0845_ _0847_ _0841_ VGND VGND VPWR VPWR _0008_ sky130_fd_sc_hd__o211a_1
XFILLER_0_34_305 VGND VGND VPWR VPWR sky130_fd_sc_hd__decap_3
X_2160_ clknet_leaf_2_clk _0240_ _0070_ VGND VGND VPWR VPWR dual_watchdog_inst.watchdog_fc.rising_edge_timeout.assert_time\[13\]
+ sky130_fd_sc_hd__dfrtp_1
XFILLER_0_29_79 VPWR VGND VPWR VGND sky130_ef_sc_hd__decap_12
XFILLER_0_29_57 VGND VGND VPWR VPWR sky130_fd_sc_hd__decap_3
XFILLER_0_29_13 VGND VGND VPWR VPWR sky130_fd_sc_hd__fill_1
X_2091_ clknet_leaf_12_clk _0171_ VGND VGND VPWR VPWR uart_tx_jetson_inst.prescale_reg\[14\]
+ sky130_fd_sc_hd__dfxtp_1
X_1042_ dual_watchdog_inst.watchdog_fc.rising_edge_timeout.assert_time\[13\] dual_watchdog_inst.watchdog_fc.rising_edge_timeout.assert_time\[12\]
+ dual_watchdog_inst.watchdog_fc.rising_edge_timeout.assert_time\[11\] _0743_ VGND
+ VGND VPWR VPWR _0744_ sky130_fd_sc_hd__and4_1
X_1111_ net222 _0740_ VGND VGND VPWR VPWR _0791_ sky130_fd_sc_hd__xnor2_1
XFILLER_0_28_132 VGND VGND VPWR VPWR sky130_fd_sc_hd__fill_2
X_1944_ _0829_ _0657_ _0658_ VGND VGND VPWR VPWR _0659_ sky130_fd_sc_hd__and3_1
XFILLER_0_0_69 VPWR VGND VPWR VGND sky130_ef_sc_hd__decap_12
X_1875_ net191 net240 VGND VGND VPWR VPWR _0629_ sky130_fd_sc_hd__nand2_1
XFILLER_0_43_3 VPWR VGND VPWR VGND sky130_ef_sc_hd__decap_12
X_1309_ net52 _0928_ VGND VGND VPWR VPWR _0000_ sky130_fd_sc_hd__nand2_2
X_2289_ clknet_leaf_0_clk _0314_ net9 VGND VGND VPWR VPWR dual_watchdog_inst.watchdog_fc.falling_edge_timeout.assert_time\[25\]
+ sky130_fd_sc_hd__dfrtp_1
XFILLER_0_42_190 VGND VGND VPWR VPWR sky130_fd_sc_hd__decap_6
XFILLER_0_15_360 VGND VGND VPWR VPWR sky130_fd_sc_hd__fill_2
XFILLER_0_19_187 VGND VGND VPWR VPWR sky130_fd_sc_hd__fill_2
XFILLER_0_31_69 VGND VGND VPWR VPWR sky130_fd_sc_hd__decap_4
XFILLER_0_25_135 VGND VGND VPWR VPWR sky130_fd_sc_hd__decap_8
XFILLER_0_25_113 VGND VGND VPWR VPWR sky130_fd_sc_hd__decap_8
Xhold209 dual_watchdog_inst.watchdog_fc.rising_edge_timeout.assert_time\[1\] VGND
+ VGND VPWR VPWR net223 sky130_fd_sc_hd__dlygate4sd3_1
X_1591_ net57 _0925_ VGND VGND VPWR VPWR _0447_ sky130_fd_sc_hd__nor2_1
X_1660_ _0495_ VGND VGND VPWR VPWR _0203_ sky130_fd_sc_hd__clkbuf_1
X_2143_ clknet_leaf_21_clk net51 VGND VGND VPWR VPWR uart_rx_jetson_inst.prescale_reg\[15\]
+ sky130_fd_sc_hd__dfxtp_1
X_2212_ clknet_leaf_27_clk _0023_ net11 VGND VGND VPWR VPWR dual_watchdog_inst.watchdog_fc.falling_edge_timeout.internal_count\[3\]
+ sky130_fd_sc_hd__dfrtp_1
X_1025_ dual_watchdog_inst.watchdog_fc.rising_edge_timeout.internal_count\[23\] _0727_
+ dual_watchdog_inst.watchdog_fc.rising_edge_timeout.internal_count\[26\] VGND VGND
+ VPWR VPWR _0728_ sky130_fd_sc_hd__or3b_1
XFILLER_0_48_249 VGND VGND VPWR VPWR sky130_fd_sc_hd__decap_3
X_2074_ clknet_leaf_9_clk _0154_ VGND VGND VPWR VPWR net5 sky130_fd_sc_hd__dfxtp_1
X_1858_ uart_tx_raspi_inst.prescale_reg\[11\] _0936_ net92 VGND VGND VPWR VPWR _0619_
+ sky130_fd_sc_hd__o21ai_1
X_1927_ dual_watchdog_inst.watchdog_fc.falling_edge_timeout.assert_time\[1\] dual_watchdog_inst.watchdog_fc.falling_edge_timeout.assert_time\[0\]
+ dual_watchdog_inst.watchdog_fc.falling_edge_timeout.assert_time\[2\] dual_watchdog_inst.watchdog_fc.falling_edge_timeout.assert_time\[3\]
+ VGND VGND VPWR VPWR _0647_ sky130_fd_sc_hd__a31o_1
X_1789_ _0570_ VGND VGND VPWR VPWR _0571_ sky130_fd_sc_hd__clkbuf_4
Xhold81 dual_watchdog_inst.watchdog_fc.rising_edge_timeout.internal_count\[1\] VGND
+ VGND VPWR VPWR net95 sky130_fd_sc_hd__dlygate4sd3_1
Xhold70 uart_tx_raspi_inst.prescale_reg\[14\] VGND VGND VPWR VPWR net84 sky130_fd_sc_hd__dlygate4sd3_1
Xsplit4 _0972_ VGND VGND VPWR VPWR net18 sky130_fd_sc_hd__dlymetal6s2s_1
Xhold92 uart_tx_raspi_inst.bit_cnt\[3\] VGND VGND VPWR VPWR net106 sky130_fd_sc_hd__dlygate4sd3_1
X_1643_ uart_rx_jetson_inst.m_axis_tdata_reg\[2\] uart_rx_jetson_inst.data_reg\[2\]
+ _0479_ VGND VGND VPWR VPWR _0484_ sky130_fd_sc_hd__mux2_1
XFILLER_0_5_349 VPWR VGND VPWR VGND sky130_ef_sc_hd__decap_12
X_1712_ _0470_ _0534_ _0536_ VGND VGND VPWR VPWR _0214_ sky130_fd_sc_hd__a21oi_1
XTAP_366 VGND VPWR sky130_fd_sc_hd__tapvpwrvgnd_1
X_1574_ _0388_ _0379_ _0436_ VGND VGND VPWR VPWR _0437_ sky130_fd_sc_hd__o21a_1
XTAP_355 VGND VPWR sky130_fd_sc_hd__tapvpwrvgnd_1
XTAP_344 VGND VPWR sky130_fd_sc_hd__tapvpwrvgnd_1
XTAP_333 VGND VPWR sky130_fd_sc_hd__tapvpwrvgnd_1
XTAP_322 VGND VPWR sky130_fd_sc_hd__tapvpwrvgnd_1
XTAP_311 VGND VPWR sky130_fd_sc_hd__tapvpwrvgnd_1
XTAP_300 VGND VPWR sky130_fd_sc_hd__tapvpwrvgnd_1
XTAP_399 VGND VPWR sky130_fd_sc_hd__tapvpwrvgnd_1
XTAP_388 VGND VPWR sky130_fd_sc_hd__tapvpwrvgnd_1
XTAP_377 VGND VPWR sky130_fd_sc_hd__tapvpwrvgnd_1
X_2057_ clknet_leaf_9_clk _0137_ VGND VGND VPWR VPWR uart_rx_raspi_inst.prescale_reg\[4\]
+ sky130_fd_sc_hd__dfxtp_1
XPHY_17 VGND VGND VPWR VPWR sky130_fd_sc_hd__decap_3
X_2126_ clknet_leaf_23_clk _0206_ VGND VGND VPWR VPWR uart_rx_jetson_inst.bit_cnt\[2\]
+ sky130_fd_sc_hd__dfxtp_1
XPHY_28 VGND VGND VPWR VPWR sky130_fd_sc_hd__decap_3
XFILLER_0_36_219 VGND VGND VPWR VPWR sky130_fd_sc_hd__decap_8
XPHY_39 VGND VGND VPWR VPWR sky130_fd_sc_hd__decap_3
XFILLER_0_50_277 VGND VGND VPWR VPWR sky130_fd_sc_hd__decap_8
XFILLER_0_53_34 VGND VGND VPWR VPWR sky130_fd_sc_hd__decap_8
XFILLER_0_53_23 VGND VGND VPWR VPWR sky130_fd_sc_hd__fill_1
X_1290_ _0737_ _0913_ _0914_ VGND VGND VPWR VPWR _0915_ sky130_fd_sc_hd__and3_1
XFILLER_0_37_57 VGND VGND VPWR VPWR sky130_fd_sc_hd__decap_4
XFILLER_0_58_333 VPWR VGND VPWR VGND sky130_ef_sc_hd__decap_12
XFILLER_0_41_299 VPWR VGND VPWR VGND sky130_ef_sc_hd__decap_12
XFILLER_0_5_113 VGND VGND VPWR VPWR sky130_fd_sc_hd__decap_4
X_1626_ uart_rx_jetson_inst.prescale_reg\[3\] uart_rx_jetson_inst.prescale_reg\[2\]
+ uart_rx_jetson_inst.prescale_reg\[1\] uart_rx_jetson_inst.prescale_reg\[0\] VGND
+ VGND VPWR VPWR _0469_ sky130_fd_sc_hd__or4_4
X_1557_ net33 _0425_ VGND VGND VPWR VPWR _0426_ sky130_fd_sc_hd__nand2_1
X_1488_ uart_tx_jetson_inst.prescale_reg\[3\] uart_tx_jetson_inst.prescale_reg\[2\]
+ uart_tx_jetson_inst.prescale_reg\[1\] uart_tx_jetson_inst.prescale_reg\[0\] VGND
+ VGND VPWR VPWR _0373_ sky130_fd_sc_hd__or4_4
XTAP_163 VGND VPWR sky130_fd_sc_hd__tapvpwrvgnd_1
XTAP_152 VGND VPWR sky130_fd_sc_hd__tapvpwrvgnd_1
XTAP_141 VGND VPWR sky130_fd_sc_hd__tapvpwrvgnd_1
XTAP_130 VGND VPWR sky130_fd_sc_hd__tapvpwrvgnd_1
XTAP_174 VGND VPWR sky130_fd_sc_hd__tapvpwrvgnd_1
XTAP_185 VGND VPWR sky130_fd_sc_hd__tapvpwrvgnd_1
XTAP_196 VGND VPWR sky130_fd_sc_hd__tapvpwrvgnd_1
X_2109_ clknet_leaf_11_clk _0189_ VGND VGND VPWR VPWR uart_rx_raspi_inst.data_reg\[1\]
+ sky130_fd_sc_hd__dfxtp_1
XFILLER_0_23_15 VGND VGND VPWR VPWR sky130_fd_sc_hd__decap_4
XFILLER_0_23_233 VGND VGND VPWR VPWR sky130_fd_sc_hd__decap_3
X_1273_ _0733_ _0900_ VGND VGND VPWR VPWR _0903_ sky130_fd_sc_hd__nand2_1
X_1411_ uart_rx_raspi_inst.bit_cnt\[2\] _1003_ VGND VGND VPWR VPWR _1010_ sky130_fd_sc_hd__nand2_1
X_1342_ uart_rx_jetson_inst.m_axis_tdata_reg\[5\] uart_tx_raspi_inst.data_reg\[6\]
+ _0930_ VGND VGND VPWR VPWR _0955_ sky130_fd_sc_hd__mux2_1
XFILLER_0_58_141 VPWR VGND VPWR VGND sky130_ef_sc_hd__decap_12
XFILLER_0_3_69 VPWR VGND VPWR VGND sky130_ef_sc_hd__decap_12
XFILLER_0_58_185 VGND VGND VPWR VPWR sky130_fd_sc_hd__fill_1
X_1609_ uart_rx_raspi_inst.data_reg\[3\] _0974_ VGND VGND VPWR VPWR _0458_ sky130_fd_sc_hd__and2_1
XFILLER_0_1_193 VPWR VGND VPWR VGND sky130_ef_sc_hd__decap_12
XFILLER_0_49_196 VGND VGND VPWR VPWR sky130_fd_sc_hd__fill_1
XFILLER_0_60_361 VGND VGND VPWR VPWR sky130_fd_sc_hd__fill_1
XFILLER_0_9_293 VGND VGND VPWR VPWR sky130_fd_sc_hd__decap_8
XFILLER_0_20_247 VGND VGND VPWR VPWR sky130_fd_sc_hd__decap_4
XFILLER_0_55_177 VGND VGND VPWR VPWR sky130_fd_sc_hd__fill_2
XFILLER_0_55_100 VGND VGND VPWR VPWR sky130_fd_sc_hd__fill_2
XFILLER_0_50_68 VGND VGND VPWR VPWR sky130_fd_sc_hd__decap_6
XFILLER_0_50_46 VGND VGND VPWR VPWR sky130_fd_sc_hd__fill_2
X_1891_ _0558_ VGND VGND VPWR VPWR _0638_ sky130_fd_sc_hd__buf_4
X_1960_ _0666_ _0669_ VGND VGND VPWR VPWR _0670_ sky130_fd_sc_hd__and2_1
XFILLER_0_51_361 VGND VGND VPWR VPWR sky130_fd_sc_hd__fill_1
X_1256_ dual_watchdog_inst.watchdog_fc.rising_edge_timeout.internal_count\[12\] _0889_
+ VGND VGND VPWR VPWR _0891_ sky130_fd_sc_hd__or2_1
X_1325_ uart_tx_raspi_inst.bit_cnt\[0\] _0942_ _0939_ VGND VGND VPWR VPWR _0943_ sky130_fd_sc_hd__a21oi_4
XFILLER_0_46_111 VGND VGND VPWR VPWR sky130_fd_sc_hd__fill_2
X_1187_ dual_watchdog_inst.watchdog_fc.falling_edge_timeout.internal_count\[14\] _0846_
+ VGND VGND VPWR VPWR _0847_ sky130_fd_sc_hd__nand2_1
XFILLER_0_24_91 VGND VGND VPWR VPWR sky130_fd_sc_hd__decap_8
XFILLER_0_46_144 VPWR VGND VPWR VGND sky130_ef_sc_hd__decap_12
XFILLER_0_6_230 VPWR VGND VPWR VGND sky130_ef_sc_hd__decap_12
XFILLER_0_37_133 VGND VGND VPWR VPWR sky130_fd_sc_hd__fill_1
XFILLER_0_20_49 VGND VGND VPWR VPWR sky130_fd_sc_hd__fill_2
X_2090_ clknet_leaf_13_clk net34 VGND VGND VPWR VPWR uart_tx_jetson_inst.prescale_reg\[13\]
+ sky130_fd_sc_hd__dfxtp_1
XFILLER_0_45_35 VGND VGND VPWR VPWR sky130_fd_sc_hd__decap_6
X_1110_ _0740_ _0741_ _0790_ _0759_ VGND VGND VPWR VPWR _0232_ sky130_fd_sc_hd__a211oi_1
XFILLER_0_45_57 VGND VGND VPWR VPWR sky130_fd_sc_hd__decap_8
X_1041_ dual_watchdog_inst.watchdog_fc.rising_edge_timeout.assert_time\[10\] dual_watchdog_inst.watchdog_fc.rising_edge_timeout.assert_time\[9\]
+ dual_watchdog_inst.watchdog_fc.rising_edge_timeout.assert_time\[8\] _0742_ VGND
+ VGND VPWR VPWR _0743_ sky130_fd_sc_hd__and4_1
XFILLER_0_0_15 VPWR VGND VPWR VGND sky130_ef_sc_hd__decap_12
X_1943_ dual_watchdog_inst.watchdog_fc.falling_edge_timeout.assert_time\[8\] _0655_
+ VGND VGND VPWR VPWR _0658_ sky130_fd_sc_hd__nand2_1
XFILLER_0_16_317 VGND VGND VPWR VPWR sky130_fd_sc_hd__decap_3
XFILLER_0_16_328 VGND VGND VPWR VPWR sky130_fd_sc_hd__decap_4
X_1874_ uart_tx_raspi_inst.bit_cnt\[0\] net240 _0941_ VGND VGND VPWR VPWR _0628_ sky130_fd_sc_hd__or3_1
XFILLER_0_24_361 VGND VGND VPWR VPWR sky130_fd_sc_hd__fill_1
XFILLER_0_10_82 VGND VGND VPWR VPWR sky130_fd_sc_hd__fill_2
X_1239_ dual_watchdog_inst.watchdog_fc.rising_edge_timeout.internal_count\[6\] _0875_
+ _0877_ VGND VGND VPWR VPWR _0880_ sky130_fd_sc_hd__nand3_1
XFILLER_0_36_3 VPWR VGND VPWR VGND sky130_ef_sc_hd__decap_12
X_1308_ rst_cnt\[6\] _0927_ VGND VGND VPWR VPWR _0928_ sky130_fd_sc_hd__and2_1
X_2288_ clknet_leaf_0_clk _0313_ net9 VGND VGND VPWR VPWR dual_watchdog_inst.watchdog_fc.falling_edge_timeout.assert_time\[24\]
+ sky130_fd_sc_hd__dfrtp_4
XFILLER_0_19_144 VGND VGND VPWR VPWR sky130_fd_sc_hd__fill_2
XFILLER_0_34_147 VGND VGND VPWR VPWR sky130_fd_sc_hd__decap_8
XFILLER_0_34_136 VGND VGND VPWR VPWR sky130_fd_sc_hd__decap_4
XFILLER_0_22_309 VGND VGND VPWR VPWR sky130_fd_sc_hd__fill_2
XFILLER_0_31_15 VPWR VGND VPWR VGND sky130_ef_sc_hd__decap_12
XFILLER_0_25_169 VGND VGND VPWR VPWR sky130_fd_sc_hd__fill_1
XFILLER_0_56_23 VGND VGND VPWR VPWR sky130_fd_sc_hd__decap_4
XFILLER_0_33_180 VGND VGND VPWR VPWR sky130_fd_sc_hd__decap_3
X_1590_ _0925_ _0000_ net22 VGND VGND VPWR VPWR _0182_ sky130_fd_sc_hd__a21oi_1
XFILLER_0_0_225 VPWR VGND VPWR VGND sky130_ef_sc_hd__decap_12
X_1024_ dual_watchdog_inst.watchdog_fc.rising_edge_timeout.internal_count\[22\] VGND
+ VGND VPWR VPWR _0727_ sky130_fd_sc_hd__inv_2
X_2073_ clknet_leaf_10_clk _0153_ VGND VGND VPWR VPWR uart_rx_raspi_inst.m_axis_tvalid_reg
+ sky130_fd_sc_hd__dfxtp_1
X_2211_ clknet_leaf_25_clk _0022_ net12 VGND VGND VPWR VPWR dual_watchdog_inst.watchdog_fc.falling_edge_timeout.internal_count\[2\]
+ sky130_fd_sc_hd__dfrtp_1
X_2142_ clknet_leaf_20_clk _0222_ VGND VGND VPWR VPWR uart_rx_jetson_inst.prescale_reg\[14\]
+ sky130_fd_sc_hd__dfxtp_1
XFILLER_0_8_347 VGND VGND VPWR VPWR sky130_fd_sc_hd__fill_2
XFILLER_0_16_103 VGND VGND VPWR VPWR sky130_fd_sc_hd__fill_1
X_1788_ _0389_ _0167_ VGND VGND VPWR VPWR _0570_ sky130_fd_sc_hd__or2b_1
X_1857_ uart_tx_raspi_inst.prescale_reg\[12\] uart_tx_raspi_inst.prescale_reg\[11\]
+ _0936_ VGND VGND VPWR VPWR _0618_ sky130_fd_sc_hd__or3_2
X_1926_ _0645_ VGND VGND VPWR VPWR _0646_ sky130_fd_sc_hd__inv_2
XFILLER_0_16_169 VGND VGND VPWR VPWR sky130_fd_sc_hd__decap_4
XFILLER_0_30_194 VGND VGND VPWR VPWR sky130_fd_sc_hd__fill_2
XFILLER_0_22_139 VGND VGND VPWR VPWR sky130_fd_sc_hd__fill_1
Xhold71 dual_watchdog_inst.watchdog_fc.rising_edge_timeout.internal_count\[3\] VGND
+ VGND VPWR VPWR net85 sky130_fd_sc_hd__dlygate4sd3_1
Xhold60 _0178_ VGND VGND VPWR VPWR net74 sky130_fd_sc_hd__dlygate4sd3_1
Xsplit5 _0940_ VGND VGND VPWR VPWR net240 sky130_fd_sc_hd__dlymetal6s2s_1
Xhold93 dual_watchdog_inst.watchdog_fc.falling_edge_timeout.assert_time\[19\] VGND
+ VGND VPWR VPWR net107 sky130_fd_sc_hd__dlygate4sd3_1
Xhold82 dual_watchdog_inst.watchdog_fc.falling_edge_timeout.internal_count\[1\] VGND
+ VGND VPWR VPWR net96 sky130_fd_sc_hd__dlygate4sd3_1
XFILLER_0_53_220 VGND VGND VPWR VPWR sky130_fd_sc_hd__decap_4
X_1642_ _0483_ VGND VGND VPWR VPWR _0197_ sky130_fd_sc_hd__clkbuf_1
XFILLER_0_5_306 VGND VGND VPWR VPWR sky130_fd_sc_hd__decap_3
X_1711_ _0535_ VGND VGND VPWR VPWR _0536_ sky130_fd_sc_hd__buf_2
XTAP_389 VGND VPWR sky130_fd_sc_hd__tapvpwrvgnd_1
XTAP_378 VGND VPWR sky130_fd_sc_hd__tapvpwrvgnd_1
X_1573_ uart_tx_jetson_inst.bit_cnt\[0\] _0380_ VGND VGND VPWR VPWR _0436_ sky130_fd_sc_hd__or2_1
XTAP_367 VGND VPWR sky130_fd_sc_hd__tapvpwrvgnd_1
XTAP_356 VGND VPWR sky130_fd_sc_hd__tapvpwrvgnd_1
XTAP_345 VGND VPWR sky130_fd_sc_hd__tapvpwrvgnd_1
XTAP_334 VGND VPWR sky130_fd_sc_hd__tapvpwrvgnd_1
XTAP_323 VGND VPWR sky130_fd_sc_hd__tapvpwrvgnd_1
XTAP_312 VGND VPWR sky130_fd_sc_hd__tapvpwrvgnd_1
XTAP_301 VGND VPWR sky130_fd_sc_hd__tapvpwrvgnd_1
X_2056_ clknet_leaf_8_clk _0136_ VGND VGND VPWR VPWR uart_rx_raspi_inst.prescale_reg\[3\]
+ sky130_fd_sc_hd__dfxtp_2
XPHY_18 VGND VGND VPWR VPWR sky130_fd_sc_hd__decap_3
XPHY_29 VGND VGND VPWR VPWR sky130_fd_sc_hd__decap_3
X_2125_ clknet_leaf_23_clk _0205_ VGND VGND VPWR VPWR uart_rx_jetson_inst.bit_cnt\[1\]
+ sky130_fd_sc_hd__dfxtp_1
X_1909_ _0639_ VGND VGND VPWR VPWR _0103_ sky130_fd_sc_hd__inv_2
XFILLER_0_4_361 VGND VGND VPWR VPWR sky130_fd_sc_hd__fill_1
XFILLER_0_2_309 VPWR VGND VPWR VGND sky130_ef_sc_hd__decap_12
Xoutput4 net4 VGND VGND VPWR VPWR reset_n_fc sky130_fd_sc_hd__clkbuf_4
XFILLER_0_58_345 VPWR VGND VPWR VGND sky130_ef_sc_hd__decap_12
X_1556_ uart_tx_jetson_inst.prescale_reg\[12\] _0410_ _0375_ VGND VGND VPWR VPWR _0425_
+ sky130_fd_sc_hd__or3_1
X_1625_ _0468_ VGND VGND VPWR VPWR _0195_ sky130_fd_sc_hd__clkbuf_1
X_1487_ uart_tx_jetson_inst.prescale_reg\[15\] uart_tx_jetson_inst.prescale_reg\[14\]
+ uart_tx_jetson_inst.prescale_reg\[13\] VGND VGND VPWR VPWR _0372_ sky130_fd_sc_hd__or3_1
XTAP_164 VGND VPWR sky130_fd_sc_hd__tapvpwrvgnd_1
XTAP_153 VGND VPWR sky130_fd_sc_hd__tapvpwrvgnd_1
XTAP_142 VGND VPWR sky130_fd_sc_hd__tapvpwrvgnd_1
XTAP_131 VGND VPWR sky130_fd_sc_hd__tapvpwrvgnd_1
XTAP_175 VGND VPWR sky130_fd_sc_hd__tapvpwrvgnd_1
XTAP_186 VGND VPWR sky130_fd_sc_hd__tapvpwrvgnd_1
XTAP_197 VGND VPWR sky130_fd_sc_hd__tapvpwrvgnd_1
X_2108_ clknet_leaf_10_clk _0188_ VGND VGND VPWR VPWR uart_rx_raspi_inst.data_reg\[0\]
+ sky130_fd_sc_hd__dfxtp_1
X_2039_ clknet_leaf_18_clk _0119_ VGND VGND VPWR VPWR uart_tx_raspi_inst.data_reg\[7\]
+ sky130_fd_sc_hd__dfxtp_1
X_1410_ _1006_ _1007_ _1009_ VGND VGND VPWR VPWR _0130_ sky130_fd_sc_hd__a21oi_1
XFILLER_0_2_117 VGND VGND VPWR VPWR sky130_fd_sc_hd__decap_3
X_1272_ dual_watchdog_inst.watchdog_fc.rising_edge_timeout.internal_count\[16\] _0900_
+ dual_watchdog_inst.watchdog_fc.rising_edge_timeout.internal_count\[17\] VGND VGND
+ VPWR VPWR _0902_ sky130_fd_sc_hd__a21o_1
XFILLER_0_3_15 VGND VGND VPWR VPWR sky130_fd_sc_hd__decap_4
X_1341_ _0954_ VGND VGND VPWR VPWR _0116_ sky130_fd_sc_hd__clkbuf_1
XFILLER_0_58_153 VPWR VGND VPWR VGND sky130_ef_sc_hd__decap_12
X_1608_ _0457_ VGND VGND VPWR VPWR _0189_ sky130_fd_sc_hd__clkbuf_1
X_1539_ _0413_ VGND VGND VPWR VPWR _0414_ sky130_fd_sc_hd__buf_2
XFILLER_0_52_307 VGND VGND VPWR VPWR sky130_fd_sc_hd__fill_1
XFILLER_0_49_175 VGND VGND VPWR VPWR sky130_fd_sc_hd__fill_1
XFILLER_0_20_226 VGND VGND VPWR VPWR sky130_fd_sc_hd__decap_4
Xhold190 dual_watchdog_inst.watchdog_fc.falling_edge_timeout.internal_count\[16\]
+ VGND VGND VPWR VPWR net204 sky130_fd_sc_hd__dlygate4sd3_1
X_1890_ _0561_ VGND VGND VPWR VPWR _0086_ sky130_fd_sc_hd__inv_2
XFILLER_0_28_348 VGND VGND VPWR VPWR sky130_fd_sc_hd__fill_1
X_1255_ net151 _0887_ _0890_ _0738_ VGND VGND VPWR VPWR _0032_ sky130_fd_sc_hd__o211a_1
X_1186_ dual_watchdog_inst.watchdog_fc.falling_edge_timeout.internal_count\[11\] dual_watchdog_inst.watchdog_fc.falling_edge_timeout.internal_count\[13\]
+ dual_watchdog_inst.watchdog_fc.falling_edge_timeout.internal_count\[12\] _0839_
+ VGND VGND VPWR VPWR _0846_ sky130_fd_sc_hd__and4_1
X_1324_ uart_tx_raspi_inst.bit_cnt\[3\] uart_tx_raspi_inst.bit_cnt\[2\] uart_tx_raspi_inst.bit_cnt\[1\]
+ VGND VGND VPWR VPWR _0942_ sky130_fd_sc_hd__nor3_2
XFILLER_0_46_156 VPWR VGND VPWR VGND sky130_ef_sc_hd__decap_12
XFILLER_0_24_81 VGND VGND VPWR VPWR sky130_fd_sc_hd__decap_3
XFILLER_0_42_351 VGND VGND VPWR VPWR sky130_fd_sc_hd__fill_2
XFILLER_0_6_242 VGND VGND VPWR VPWR sky130_fd_sc_hd__decap_8
XFILLER_0_6_253 VPWR VGND VPWR VGND sky130_ef_sc_hd__decap_12
XFILLER_0_10_292 VGND VGND VPWR VPWR sky130_fd_sc_hd__fill_1
XFILLER_0_37_156 VPWR VGND VPWR VGND sky130_ef_sc_hd__decap_12
XFILLER_0_60_181 VPWR VGND VPWR VGND sky130_ef_sc_hd__decap_12
XFILLER_0_33_351 VGND VGND VPWR VPWR sky130_fd_sc_hd__decap_3
X_1040_ dual_watchdog_inst.watchdog_fc.rising_edge_timeout.assert_time\[7\] dual_watchdog_inst.watchdog_fc.rising_edge_timeout.assert_time\[6\]
+ _0740_ _0741_ VGND VGND VPWR VPWR _0742_ sky130_fd_sc_hd__and4_1
XFILLER_0_28_112 VPWR VGND VPWR VGND sky130_ef_sc_hd__decap_12
X_1942_ dual_watchdog_inst.watchdog_fc.falling_edge_timeout.assert_time\[8\] _0655_
+ VGND VGND VPWR VPWR _0657_ sky130_fd_sc_hd__or2_1
XFILLER_0_0_27 VGND VGND VPWR VPWR sky130_fd_sc_hd__fill_1
X_1873_ _0627_ VGND VGND VPWR VPWR _0284_ sky130_fd_sc_hd__clkbuf_1
X_1238_ _0875_ _0877_ dual_watchdog_inst.watchdog_fc.rising_edge_timeout.internal_count\[6\]
+ VGND VGND VPWR VPWR _0879_ sky130_fd_sc_hd__a21o_1
XFILLER_0_29_3 VGND VGND VPWR VPWR sky130_fd_sc_hd__decap_6
X_1169_ dual_watchdog_inst.watchdog_fc.falling_edge_timeout.internal_count\[8\] _0834_
+ VGND VGND VPWR VPWR _0835_ sky130_fd_sc_hd__nor2_1
X_1307_ rst_cnt\[5\] rst_cnt\[4\] _0926_ VGND VGND VPWR VPWR _0927_ sky130_fd_sc_hd__and3_1
X_2287_ clknet_leaf_0_clk net159 net9 VGND VGND VPWR VPWR dual_watchdog_inst.watchdog_fc.falling_edge_timeout.assert_time\[23\]
+ sky130_fd_sc_hd__dfrtp_1
XFILLER_0_59_281 VPWR VGND VPWR VGND sky130_ef_sc_hd__decap_12
XFILLER_0_31_27 VGND VGND VPWR VPWR sky130_fd_sc_hd__decap_6
XFILLER_0_25_159 VGND VGND VPWR VPWR sky130_fd_sc_hd__decap_4
XFILLER_0_56_35 VGND VGND VPWR VPWR sky130_fd_sc_hd__fill_1
XFILLER_0_0_237 VPWR VGND VPWR VGND sky130_ef_sc_hd__decap_12
X_2210_ clknet_leaf_25_clk _0014_ net12 VGND VGND VPWR VPWR dual_watchdog_inst.watchdog_fc.falling_edge_timeout.internal_count\[1\]
+ sky130_fd_sc_hd__dfrtp_1
X_1023_ _0721_ _0722_ _0725_ VGND VGND VPWR VPWR _0726_ sky130_fd_sc_hd__nor3_1
X_2141_ clknet_leaf_20_clk _0221_ VGND VGND VPWR VPWR uart_rx_jetson_inst.prescale_reg\[13\]
+ sky130_fd_sc_hd__dfxtp_1
X_2072_ clknet_leaf_23_clk _0152_ VGND VGND VPWR VPWR uart_rx_jetson_inst.rxd_reg
+ sky130_fd_sc_hd__dfxtp_2
X_1925_ dual_watchdog_inst.watchdog_fc.falling_edge_timeout.assert_time\[1\] dual_watchdog_inst.watchdog_fc.falling_edge_timeout.assert_time\[0\]
+ dual_watchdog_inst.watchdog_fc.falling_edge_timeout.assert_time\[3\] dual_watchdog_inst.watchdog_fc.falling_edge_timeout.assert_time\[2\]
+ VGND VGND VPWR VPWR _0645_ sky130_fd_sc_hd__and4_2
X_1787_ uart_rx_raspi_inst.m_axis_tdata_reg\[0\] uart_tx_jetson_inst.data_reg\[1\]
+ _0383_ VGND VGND VPWR VPWR _0569_ sky130_fd_sc_hd__mux2_1
X_1856_ _0616_ _0617_ _0609_ VGND VGND VPWR VPWR _0277_ sky130_fd_sc_hd__o21ba_1
XFILLER_0_1_81 VPWR VGND VPWR VGND sky130_ef_sc_hd__decap_12
XFILLER_0_47_295 VGND VGND VPWR VPWR sky130_fd_sc_hd__decap_3
XFILLER_0_47_262 VPWR VGND VPWR VGND sky130_ef_sc_hd__decap_12
Xhold61 uart_tx_jetson_inst.prescale_reg\[9\] VGND VGND VPWR VPWR net75 sky130_fd_sc_hd__dlygate4sd3_1
Xhold83 dual_watchdog_inst.watchdog_fc.rising_edge_timeout.internal_count\[4\] VGND
+ VGND VPWR VPWR net97 sky130_fd_sc_hd__dlygate4sd3_1
Xhold94 uart_rx_raspi_inst.bit_cnt\[2\] VGND VGND VPWR VPWR net108 sky130_fd_sc_hd__dlygate4sd3_1
Xhold50 uart_rx_raspi_inst.prescale_reg\[17\] VGND VGND VPWR VPWR net64 sky130_fd_sc_hd__dlygate4sd3_1
XFILLER_0_26_27 VGND VGND VPWR VPWR sky130_fd_sc_hd__fill_1
Xhold72 uart_rx_jetson_inst.m_axis_tvalid_reg VGND VGND VPWR VPWR net86 sky130_fd_sc_hd__dlygate4sd3_1
XFILLER_0_42_15 VGND VGND VPWR VPWR sky130_fd_sc_hd__decap_8
XFILLER_0_38_284 VPWR VGND VPWR VGND sky130_ef_sc_hd__decap_12
X_1572_ _0435_ VGND VGND VPWR VPWR _0175_ sky130_fd_sc_hd__clkbuf_1
X_1641_ _0986_ _0482_ VGND VGND VPWR VPWR _0483_ sky130_fd_sc_hd__and2b_1
XFILLER_0_6_15 VGND VGND VPWR VPWR sky130_fd_sc_hd__decap_8
X_1710_ uart_rst _0504_ VGND VGND VPWR VPWR _0535_ sky130_fd_sc_hd__or2_1
XFILLER_0_21_162 VGND VGND VPWR VPWR sky130_fd_sc_hd__decap_6
XTAP_379 VGND VPWR sky130_fd_sc_hd__tapvpwrvgnd_1
XTAP_368 VGND VPWR sky130_fd_sc_hd__tapvpwrvgnd_1
XTAP_357 VGND VPWR sky130_fd_sc_hd__tapvpwrvgnd_1
XTAP_346 VGND VPWR sky130_fd_sc_hd__tapvpwrvgnd_1
XTAP_335 VGND VPWR sky130_fd_sc_hd__tapvpwrvgnd_1
XTAP_324 VGND VPWR sky130_fd_sc_hd__tapvpwrvgnd_1
XTAP_313 VGND VPWR sky130_fd_sc_hd__tapvpwrvgnd_1
XTAP_302 VGND VPWR sky130_fd_sc_hd__tapvpwrvgnd_1
X_2124_ clknet_leaf_20_clk _0204_ VGND VGND VPWR VPWR uart_rx_jetson_inst.bit_cnt\[0\]
+ sky130_fd_sc_hd__dfxtp_1
X_2055_ clknet_leaf_8_clk _0135_ VGND VGND VPWR VPWR uart_rx_raspi_inst.prescale_reg\[2\]
+ sky130_fd_sc_hd__dfxtp_1
XPHY_19 VGND VGND VPWR VPWR sky130_fd_sc_hd__decap_3
XFILLER_0_16_93 VGND VGND VPWR VPWR sky130_fd_sc_hd__decap_3
X_1908_ _0639_ VGND VGND VPWR VPWR _0102_ sky130_fd_sc_hd__inv_2
XFILLER_0_29_262 VGND VGND VPWR VPWR sky130_fd_sc_hd__decap_4
X_1839_ _1002_ net239 _0605_ VGND VGND VPWR VPWR _0272_ sky130_fd_sc_hd__nor3_1
XFILLER_0_8_134 VGND VGND VPWR VPWR sky130_fd_sc_hd__decap_6
Xoutput5 net5 VGND VGND VPWR VPWR txd_jetson sky130_fd_sc_hd__clkbuf_4
XFILLER_0_37_15 VGND VGND VPWR VPWR sky130_fd_sc_hd__decap_8
XFILLER_0_58_357 VGND VGND VPWR VPWR sky130_fd_sc_hd__decap_4
XFILLER_0_53_69 VPWR VGND VPWR VGND sky130_ef_sc_hd__decap_12
Xclkbuf_leaf_28_clk clknet_2_0__leaf_clk VGND VGND VPWR VPWR clknet_leaf_28_clk sky130_fd_sc_hd__clkbuf_16
X_1555_ _0376_ _0424_ _0414_ VGND VGND VPWR VPWR _0169_ sky130_fd_sc_hd__o21ba_1
X_1624_ _0975_ net156 _0454_ VGND VGND VPWR VPWR _0468_ sky130_fd_sc_hd__mux2_1
XTAP_132 VGND VPWR sky130_fd_sc_hd__tapvpwrvgnd_1
X_1486_ uart_tx_jetson_inst.bit_cnt\[0\] _0369_ VGND VGND VPWR VPWR _0371_ sky130_fd_sc_hd__or2_1
XTAP_165 VGND VPWR sky130_fd_sc_hd__tapvpwrvgnd_1
XTAP_154 VGND VPWR sky130_fd_sc_hd__tapvpwrvgnd_1
XTAP_143 VGND VPWR sky130_fd_sc_hd__tapvpwrvgnd_1
XTAP_176 VGND VPWR sky130_fd_sc_hd__tapvpwrvgnd_1
XTAP_187 VGND VPWR sky130_fd_sc_hd__tapvpwrvgnd_1
X_2107_ clknet_leaf_22_clk _0187_ VGND VGND VPWR VPWR rst_cnt\[7\] sky130_fd_sc_hd__dfxtp_1
XTAP_198 VGND VPWR sky130_fd_sc_hd__tapvpwrvgnd_1
Xclkbuf_leaf_19_clk clknet_2_2__leaf_clk VGND VGND VPWR VPWR clknet_leaf_19_clk sky130_fd_sc_hd__clkbuf_16
XFILLER_0_49_335 VGND VGND VPWR VPWR sky130_fd_sc_hd__fill_1
XFILLER_0_11_3 VPWR VGND VPWR VGND sky130_ef_sc_hd__decap_12
X_2038_ clknet_leaf_18_clk _0118_ VGND VGND VPWR VPWR uart_tx_raspi_inst.data_reg\[6\]
+ sky130_fd_sc_hd__dfxtp_1
XFILLER_0_32_257 VGND VGND VPWR VPWR sky130_fd_sc_hd__fill_1
XFILLER_0_32_202 VPWR VGND VPWR VGND sky130_ef_sc_hd__decap_12
XFILLER_0_23_39 VGND VGND VPWR VPWR sky130_fd_sc_hd__decap_8
X_1340_ _0953_ net170 net15 VGND VGND VPWR VPWR _0954_ sky130_fd_sc_hd__mux2_4
X_1271_ net149 _0900_ _0901_ VGND VGND VPWR VPWR _0037_ sky130_fd_sc_hd__o21ba_1
XFILLER_0_58_165 VPWR VGND VPWR VGND sky130_ef_sc_hd__decap_12
XFILLER_0_46_305 VGND VGND VPWR VPWR sky130_fd_sc_hd__decap_3
Xclkbuf_leaf_8_clk clknet_2_1__leaf_clk VGND VGND VPWR VPWR clknet_leaf_8_clk sky130_fd_sc_hd__clkbuf_16
XFILLER_0_13_61 VGND VGND VPWR VPWR sky130_fd_sc_hd__fill_1
XFILLER_0_14_257 VGND VGND VPWR VPWR sky130_fd_sc_hd__fill_1
XFILLER_0_59_3 VPWR VGND VPWR VGND sky130_ef_sc_hd__decap_12
X_1607_ _0456_ net192 _0454_ VGND VGND VPWR VPWR _0457_ sky130_fd_sc_hd__mux2_1
X_1538_ _0963_ _0379_ VGND VGND VPWR VPWR _0413_ sky130_fd_sc_hd__or2_1
X_1469_ net102 _0359_ VGND VGND VPWR VPWR _0361_ sky130_fd_sc_hd__xnor2_1
XFILLER_0_49_110 VGND VGND VPWR VPWR sky130_fd_sc_hd__fill_2
XFILLER_0_49_165 VGND VGND VPWR VPWR sky130_fd_sc_hd__decap_3
Xhold180 uart_rx_jetson_inst.data_reg\[1\] VGND VGND VPWR VPWR net194 sky130_fd_sc_hd__dlygate4sd3_1
Xhold191 dual_watchdog_inst.watchdog_fc.rising_edge_timeout.internal_count\[24\] VGND
+ VGND VPWR VPWR net205 sky130_fd_sc_hd__dlygate4sd3_1
XFILLER_0_0_3 VPWR VGND VPWR VGND sky130_ef_sc_hd__decap_12
XFILLER_0_18_39 VGND VGND VPWR VPWR sky130_fd_sc_hd__decap_6
XFILLER_0_55_113 VGND VGND VPWR VPWR sky130_fd_sc_hd__decap_4
XFILLER_0_51_341 VGND VGND VPWR VPWR sky130_fd_sc_hd__decap_4
XFILLER_0_50_37 VGND VGND VPWR VPWR sky130_fd_sc_hd__fill_1
XFILLER_0_43_308 VGND VGND VPWR VPWR sky130_fd_sc_hd__fill_1
XFILLER_0_36_360 VGND VGND VPWR VPWR sky130_fd_sc_hd__fill_2
XFILLER_0_59_57 VGND VGND VPWR VPWR sky130_fd_sc_hd__decap_4
X_1323_ uart_rx_jetson_inst.m_axis_tvalid_reg _0929_ VGND VGND VPWR VPWR _0941_ sky130_fd_sc_hd__nor2_1
X_1254_ _0889_ VGND VGND VPWR VPWR _0890_ sky130_fd_sc_hd__inv_2
X_1185_ net118 _0844_ _0845_ VGND VGND VPWR VPWR _0007_ sky130_fd_sc_hd__o21ba_1
XFILLER_0_46_168 VGND VGND VPWR VPWR sky130_fd_sc_hd__decap_4
XFILLER_0_6_265 VGND VGND VPWR VPWR sky130_fd_sc_hd__fill_2
XFILLER_0_4_81 VGND VGND VPWR VPWR sky130_fd_sc_hd__decap_3
XFILLER_0_33_341 VGND VGND VPWR VPWR sky130_fd_sc_hd__fill_1
XFILLER_0_18_360 VGND VGND VPWR VPWR sky130_fd_sc_hd__fill_2
XFILLER_0_60_193 VGND VGND VPWR VPWR sky130_fd_sc_hd__decap_3
XFILLER_0_45_15 VPWR VGND VPWR VGND sky130_ef_sc_hd__decap_12
X_1872_ _0964_ _0564_ uart_tx_raspi_inst.prescale_reg\[18\] VGND VGND VPWR VPWR _0627_
+ sky130_fd_sc_hd__and3b_1
XFILLER_0_28_124 VGND VGND VPWR VPWR sky130_fd_sc_hd__decap_8
X_1941_ net78 _0654_ _0656_ VGND VGND VPWR VPWR _0296_ sky130_fd_sc_hd__o21a_1
XFILLER_0_51_160 VGND VGND VPWR VPWR sky130_fd_sc_hd__decap_8
XFILLER_0_3_279 VGND VGND VPWR VPWR sky130_fd_sc_hd__fill_1
X_1306_ rst_cnt\[3\] _0925_ VGND VGND VPWR VPWR _0926_ sky130_fd_sc_hd__and2_1
X_2286_ clknet_leaf_29_clk _0311_ net8 VGND VGND VPWR VPWR dual_watchdog_inst.watchdog_fc.falling_edge_timeout.assert_time\[22\]
+ sky130_fd_sc_hd__dfrtp_1
X_1237_ _0875_ _0877_ net72 VGND VGND VPWR VPWR _0052_ sky130_fd_sc_hd__a21oi_1
X_1099_ net172 _0782_ _0783_ VGND VGND VPWR VPWR _0236_ sky130_fd_sc_hd__o21a_1
X_1168_ _0833_ VGND VGND VPWR VPWR _0834_ sky130_fd_sc_hd__clkbuf_2
XFILLER_0_19_113 VGND VGND VPWR VPWR sky130_fd_sc_hd__fill_1
XFILLER_0_59_293 VPWR VGND VPWR VGND sky130_ef_sc_hd__decap_12
XFILLER_0_15_352 VGND VGND VPWR VPWR sky130_fd_sc_hd__decap_8
XFILLER_0_19_124 VPWR VGND VPWR VGND sky130_ef_sc_hd__decap_12
XFILLER_0_19_179 VGND VGND VPWR VPWR sky130_fd_sc_hd__decap_8
XFILLER_0_25_127 VGND VGND VPWR VPWR sky130_fd_sc_hd__fill_1
XFILLER_0_0_249 VGND VGND VPWR VPWR sky130_fd_sc_hd__decap_3
X_2140_ clknet_leaf_20_clk _0220_ VGND VGND VPWR VPWR uart_rx_jetson_inst.prescale_reg\[12\]
+ sky130_fd_sc_hd__dfxtp_1
X_1022_ dual_watchdog_inst.watchdog_fc.rising_edge_timeout.assert_time\[26\] dual_watchdog_inst.watchdog_fc.rising_edge_timeout.assert_time\[25\]
+ _0723_ _0724_ VGND VGND VPWR VPWR _0725_ sky130_fd_sc_hd__or4_1
X_2071_ clknet_leaf_9_clk _0151_ VGND VGND VPWR VPWR uart_rx_raspi_inst.prescale_reg\[18\]
+ sky130_fd_sc_hd__dfxtp_1
X_1855_ uart_tx_raspi_inst.prescale_reg\[11\] _0936_ VGND VGND VPWR VPWR _0617_ sky130_fd_sc_hd__and2_1
XFILLER_0_16_138 VGND VGND VPWR VPWR sky130_fd_sc_hd__fill_2
X_1924_ _0644_ VGND VGND VPWR VPWR _0291_ sky130_fd_sc_hd__clkbuf_1
XFILLER_0_21_50 VGND VGND VPWR VPWR sky130_fd_sc_hd__fill_1
X_1786_ _0562_ _0930_ _0568_ _0940_ VGND VGND VPWR VPWR _0256_ sky130_fd_sc_hd__a211oi_1
X_2269_ clknet_leaf_28_clk _0294_ net7 VGND VGND VPWR VPWR dual_watchdog_inst.watchdog_fc.falling_edge_timeout.assert_time\[5\]
+ sky130_fd_sc_hd__dfrtp_1
XFILLER_0_47_274 VGND VGND VPWR VPWR sky130_fd_sc_hd__decap_6
XFILLER_0_1_93 VPWR VGND VPWR VGND sky130_ef_sc_hd__decap_12
XFILLER_0_30_174 VGND VGND VPWR VPWR sky130_fd_sc_hd__fill_1
Xhold40 _0828_ VGND VGND VPWR VPWR net54 sky130_fd_sc_hd__dlygate4sd3_1
Xhold62 _0418_ VGND VGND VPWR VPWR net76 sky130_fd_sc_hd__dlygate4sd3_1
Xhold95 dual_watchdog_inst.watchdog_fc.rising_edge_timeout.internal_count\[2\] VGND
+ VGND VPWR VPWR net109 sky130_fd_sc_hd__dlygate4sd3_1
Xhold84 dual_watchdog_inst.watchdog_fc.rising_edge_timeout.assert_time\[17\] VGND
+ VGND VPWR VPWR net98 sky130_fd_sc_hd__dlygate4sd3_1
Xhold73 dual_watchdog_inst.watchdog_fc.rising_edge_timeout.assert_time\[13\] VGND
+ VGND VPWR VPWR net87 sky130_fd_sc_hd__dlygate4sd3_1
Xhold51 _0365_ VGND VGND VPWR VPWR net65 sky130_fd_sc_hd__dlygate4sd3_1
XFILLER_0_26_39 VGND VGND VPWR VPWR sky130_fd_sc_hd__fill_1
XFILLER_0_38_296 VGND VGND VPWR VPWR sky130_fd_sc_hd__decap_8
X_1571_ _0964_ _0433_ net198 VGND VGND VPWR VPWR _0435_ sky130_fd_sc_hd__and3b_1
XTAP_314 VGND VPWR sky130_fd_sc_hd__tapvpwrvgnd_1
X_1640_ uart_rx_jetson_inst.m_axis_tdata_reg\[1\] uart_rx_jetson_inst.data_reg\[1\]
+ _0479_ VGND VGND VPWR VPWR _0482_ sky130_fd_sc_hd__mux2_1
XTAP_303 VGND VPWR sky130_fd_sc_hd__tapvpwrvgnd_1
XTAP_369 VGND VPWR sky130_fd_sc_hd__tapvpwrvgnd_1
XTAP_358 VGND VPWR sky130_fd_sc_hd__tapvpwrvgnd_1
XTAP_347 VGND VPWR sky130_fd_sc_hd__tapvpwrvgnd_1
XTAP_336 VGND VPWR sky130_fd_sc_hd__tapvpwrvgnd_1
XTAP_325 VGND VPWR sky130_fd_sc_hd__tapvpwrvgnd_1
X_2123_ clknet_leaf_18_clk _0203_ VGND VGND VPWR VPWR uart_rx_jetson_inst.m_axis_tdata_reg\[7\]
+ sky130_fd_sc_hd__dfxtp_1
X_2054_ clknet_leaf_8_clk _0134_ VGND VGND VPWR VPWR uart_rx_raspi_inst.prescale_reg\[1\]
+ sky130_fd_sc_hd__dfxtp_1
X_1907_ _0639_ VGND VGND VPWR VPWR _0101_ sky130_fd_sc_hd__inv_2
XFILLER_0_29_285 VGND VGND VPWR VPWR sky130_fd_sc_hd__decap_8
X_1838_ net228 _0602_ VGND VGND VPWR VPWR _0605_ sky130_fd_sc_hd__xor2_1
X_1769_ _0558_ VGND VGND VPWR VPWR _0561_ sky130_fd_sc_hd__buf_4
Xoutput6 net6 VGND VGND VPWR VPWR txd_raspi sky130_fd_sc_hd__clkbuf_4
X_1554_ _0410_ _0375_ net181 VGND VGND VPWR VPWR _0424_ sky130_fd_sc_hd__o21a_1
X_1623_ _0467_ VGND VGND VPWR VPWR _0194_ sky130_fd_sc_hd__clkbuf_1
X_1485_ uart_tx_jetson_inst.bit_cnt\[0\] uart_tx_jetson_inst.data_reg\[0\] _0369_
+ VGND VGND VPWR VPWR _0370_ sky130_fd_sc_hd__mux2_1
XTAP_166 VGND VPWR sky130_fd_sc_hd__tapvpwrvgnd_1
XTAP_155 VGND VPWR sky130_fd_sc_hd__tapvpwrvgnd_1
XTAP_144 VGND VPWR sky130_fd_sc_hd__tapvpwrvgnd_1
XTAP_122 VGND VPWR sky130_fd_sc_hd__tapvpwrvgnd_1
XTAP_133 VGND VPWR sky130_fd_sc_hd__tapvpwrvgnd_1
.ends
